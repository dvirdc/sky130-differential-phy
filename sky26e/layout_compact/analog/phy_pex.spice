* NGSPICE file created from phy_pex.ext - technology: sky130A

.subckt phy_pex din boost rxp rxn txp txn dout VDPWR VGND
X0 VDPWR.t8 xi0_xn.D.t6 xi1_xn.D.t3 VDPWR.t7 sky130_fd_pr__pfet_01v8 ad=1.16 pd=8.58 as=1.16 ps=8.58 w=4 l=0.15
X1 VGND.t1 boost.t0 xib_xn.D.t0 VGND.t3 sky130_fd_pr__nfet_01v8 ad=0.58 pd=4.58 as=0.58 ps=4.58 w=2 l=0.15
X2 xtn_xn.S.t1 boost.t3 xi0_xn.D.t1 VGND.t10 sky130_fd_pr__nfet_01v8 ad=1.16 pd=8.58 as=1.16 ps=8.58 w=4 l=0.15
X3 xtn_xn.S.t2 xib_xn.D.t3 xi0_xn.D.t4 VDPWR.t18 sky130_fd_pr__pfet_01v8 ad=2.32 pd=16.58 as=2.32 ps=16.58 w=8 l=0.15
X4 txn.t1 xrbp.R2 VGND.t16 sky130_fd_pr__res_high_po_0p35 l=1
X5 VDPWR.t10 xis_xn.D.t3 xbuf_xn.D.t0 VDPWR.t9 sky130_fd_pr__pfet_01v8 ad=1.16 pd=8.58 as=1.16 ps=8.58 w=4 l=0.15
X6 xi1_xn.D.t0 txp.t0 VGND.t13 sky130_fd_pr__res_high_po_0p35 l=28
X7 VGND.t1 xis_xn.D.t2 xbuf_xn.D.t1 VGND.t7 sky130_fd_pr__nfet_01v8 ad=0.58 pd=4.58 as=0.58 ps=4.58 w=2 l=0.15
X8 VDPWR.t14 xn1.D.t3 xis_xn.G.t1 VDPWR.t13 sky130_fd_pr__pfet_01v8 ad=3.48 pd=24.58 as=3.48 ps=24.58 w=12 l=1
X9 VGND.t1 din.t0 xi0_xn.D.t2 VGND.t4 sky130_fd_pr__nfet_01v8 ad=0.58 pd=4.58 as=0.58 ps=4.58 w=2 l=0.15
X10 xtp_xn.S.t2 xib_xn.D.t2 xi1_xn.D.t4 VDPWR.t17 sky130_fd_pr__pfet_01v8 ad=2.32 pd=16.58 as=2.32 ps=16.58 w=8 l=0.15
X11 VDPWR.t2 boost.t1 xib_xn.D.t1 VDPWR.t1 sky130_fd_pr__pfet_01v8 ad=1.16 pd=8.58 as=1.16 ps=8.58 w=4 l=0.15
X12 txp.t1 xrbp.R2 VGND.t15 sky130_fd_pr__res_high_po_0p35 l=1
X13 VDPWR.t4 din.t1 xi0_xn.D.t3 VDPWR.t3 sky130_fd_pr__pfet_01v8 ad=1.16 pd=8.58 as=1.16 ps=8.58 w=4 l=0.15
X14 VDPWR.t16 xn1.D.t1 xn1.D.t2 VDPWR.t15 sky130_fd_pr__pfet_01v8 ad=3.48 pd=24.58 as=3.48 ps=24.58 w=12 l=1
X15 xtp_xn.S.t1 boost.t2 xi1_xn.D.t1 VGND.t9 sky130_fd_pr__nfet_01v8 ad=1.16 pd=8.58 as=1.16 ps=8.58 w=4 l=0.15
X16 xn1.S.t2 rxp.t0 xis_xn.G.t0 VGND.t12 sky130_fd_pr__nfet_01v8 ad=6.96 pd=48.58 as=6.96 ps=48.58 w=24 l=1
X17 xtn_xn.S.t0 txn.t2 VGND.t19 sky130_fd_pr__res_high_po_0p35 l=28
X18 xrbp.R2 VGND.t1 VGND.t0 sky130_fd_pr__res_high_po_0p35 l=20
X19 VGND.t1 xis_xn.G.t2 xis_xn.D.t1 VGND.t8 sky130_fd_pr__nfet_01v8 ad=0.58 pd=4.58 as=0.58 ps=4.58 w=2 l=0.15
X20 xn1.S.t1 rxn.t0 xn1.D.t0 VGND.t11 sky130_fd_pr__nfet_01v8 ad=6.96 pd=48.58 as=6.96 ps=48.58 w=24 l=1
X21 VGND.t1 xbuf_xn.D.t2 dout.t1 VGND.t5 sky130_fd_pr__nfet_01v8 ad=0.58 pd=4.58 as=0.58 ps=4.58 w=2 l=0.15
X22 VGND.t1 xi0_xn.D.t5 xi1_xn.D.t2 VGND.t6 sky130_fd_pr__nfet_01v8 ad=0.58 pd=4.58 as=0.58 ps=4.58 w=2 l=0.15
X23 xi0_xn.D.t0 txn.t0 VGND.t14 sky130_fd_pr__res_high_po_0p35 l=28
X24 xtp_xn.S.t0 txp.t2 VGND.t18 sky130_fd_pr__res_high_po_0p35 l=28
X25 VDPWR.t12 xis_xn.G.t3 xis_xn.D.t0 VDPWR.t11 sky130_fd_pr__pfet_01v8 ad=1.16 pd=8.58 as=1.16 ps=8.58 w=4 l=0.15
X26 VDPWR.t6 xbuf_xn.D.t3 dout.t0 VDPWR.t5 sky130_fd_pr__pfet_01v8 ad=1.16 pd=8.58 as=1.16 ps=8.58 w=4 l=0.15
X27 VDPWR.t0 xrbp.R2 VGND.t17 sky130_fd_pr__res_high_po_0p35 l=20
X28 xn1.S.t0 VGND.t1 VGND.t2 sky130_fd_pr__res_high_po_0p35 l=20
R0 xtp_xn.S.t0 xtp_xn.S.t1 285.57
R1 xtp_xn.S.t0 xtp_xn.S.t2 317.488
R2 xtp_xn.S.t1 xtp_xn.S.t2 167.861
R3 xtn_xn.S.t0 xtn_xn.S.t1 286.779
R4 xtn_xn.S.t0 xtn_xn.S.t2 318.471
R5 xtn_xn.S.t1 xtn_xn.S.t2 170.029
R6 xn1.S.t0 xn1.S.t1 326.087
R7 xn1.S.t0 xn1.S.t2 324.678
R8 xn1.S.t1 xn1.S.t2 377.618
R9 xn1.D.t0 xn1.D.n0 123.507
R10 xn1.D.n0 xn1.D.t2 54.5395
R11 xn1.D.t3 xn1.D.n0 468.69
R12 xn1.D.t3 xn1.D.t1 6014.7
R13 xn1.D.n0 xn1.D.t1 468.092
R14 xis_xn.G.t0 xis_xn.G.n0 122.793
R15 xis_xn.G.n0 xis_xn.G.t1 53.8252
R16 xis_xn.G.t3 xis_xn.G.n0 975.409
R17 xis_xn.G.t3 xis_xn.G.t2 21784.4
R18 xis_xn.G.n0 xis_xn.G.t2 615.538
R19 xis_xn.D.n0 xis_xn.D.t1 124.672
R20 xis_xn.D.t0 xis_xn.D.n0 94.194
R21 xis_xn.D.t3 xis_xn.D.n0 963.725
R22 xis_xn.D.t3 xis_xn.D.t2 26491.8
R23 xis_xn.D.n0 xis_xn.D.t2 608.444
R24 xib_xn.D.n0 xib_xn.D.t0 130.387
R25 xib_xn.D.t1 xib_xn.D.n0 99.9083
R26 xib_xn.D.t3 xib_xn.D.n0 1593.33
R27 xib_xn.D.t3 xib_xn.D.t2 102748
R28 xib_xn.D.n0 xib_xn.D.t2 1592.27
R29 xi1_xn.D.n0 xi1_xn.D.t0 109.556
R30 xi1_xn.D.t4 xi1_xn.D.n0 64.1306
R31 xi1_xn.D.n0 xi1_xn.D.t1 56.6636
R32 xi1_xn.D.n0 xi1_xn.D.t2 139.373
R33 xi1_xn.D.n0 xi1_xn.D.t3 104.88
R34 xi1_xn.D.t2 xi1_xn.D.t3 2583.07
R35 xi0_xn.D.n0 xi0_xn.D.t2 128.244
R36 xi0_xn.D.n1 xi0_xn.D.t0 110.469
R37 xi0_xn.D.n0 xi0_xn.D.t3 97.2482
R38 xi0_xn.D.t4 xi0_xn.D.n1 65.5592
R39 xi0_xn.D.n1 xi0_xn.D.t1 58.0921
R40 xi0_xn.D.n1 xi0_xn.D.n0 7.7555
R41 xi0_xn.D.t6 xi0_xn.D.n0 946.61
R42 xi0_xn.D.t6 xi0_xn.D.t5 34568.6
R43 xi0_xn.D.n0 xi0_xn.D.t5 596.264
R44 xbuf_xn.D.n0 xbuf_xn.D.t1 123.957
R45 xbuf_xn.D.t0 xbuf_xn.D.n0 93.4797
R46 xbuf_xn.D.t3 xbuf_xn.D.n0 969.28
R47 xbuf_xn.D.t3 xbuf_xn.D.t2 24475.4
R48 xbuf_xn.D.n0 xbuf_xn.D.t2 612.232
R49 txp.n0 txp.t1 87.5001
R50 txp.n0 txp.t2 73.3634
R51 txp.n0 txp.t0 71.1544
R52 txp txp.n0 38.2518
R53 txn.n0 txn.t1 88.2144
R54 txn.n0 txn.t2 74.0777
R55 txn.n0 txn.t0 71.8687
R56 txn txn.n0 38.9567
R57 rxp rxp.t0 698.936
R58 rxn rxn.t0 698.739
R59 dout.t0 dout 156.875
R60 dout.t0 dout.t1 588.903
R61 dout dout.t1 206.142
R62 din din.t0 593.216
R63 din din.t1 940.818
R64 din.t0 din.t1 38684.9
R65 boost.t0 boost.t1 902.79
R66 boost boost.t3 7.15625
R67 boost.t2 boost.t0 3.6195
R68 boost.t3 boost.t2 1.0345
R69 VGND.n101 VGND.n100 1247.61
R70 VGND.n97 VGND.n96 1198.58
R71 VGND.n98 VGND.n97 1198.58
R72 VGND.n99 VGND.n98 1198.58
R73 VGND.n100 VGND.n99 1198.58
R74 VGND.n95 VGND.n94 1169.61
R75 VGND.n94 VGND.n93 1169.61
R76 VGND.n93 VGND.n92 1169.61
R77 VGND.n92 VGND.n91 1169.61
R78 VGND.n6 VGND.n4 584.25
R79 VGND.n10 VGND.n7 585
R80 VGND.n18 VGND.n17 585
R81 VGND.n22 VGND.n19 585
R82 VGND.n28 VGND.n27 585
R83 VGND.n32 VGND.n29 585
R84 VGND.n38 VGND.n37 585
R85 VGND.n42 VGND.n39 585
R86 VGND.n48 VGND.n47 585
R87 VGND.n52 VGND.n49 585
R88 VGND.n58 VGND.n57 585
R89 VGND.n62 VGND.n59 585
R90 VGND.n68 VGND.n67 585
R91 VGND.n72 VGND.n69 585
R92 VGND.n112 VGND.n74 585
R93 VGND.n114 VGND.n70 585
R94 VGND.n116 VGND.n65 585
R95 VGND.n118 VGND.n60 585
R96 VGND.n120 VGND.n55 585
R97 VGND.n122 VGND.n50 585
R98 VGND.n124 VGND.n45 585
R99 VGND.n127 VGND.n40 585
R100 VGND.n129 VGND.n35 585
R101 VGND.n131 VGND.n30 585
R102 VGND.n133 VGND.n25 585
R103 VGND.n135 VGND.n20 585
R104 VGND.n137 VGND.n15 585
R105 VGND.n139 VGND.n8 585
R106 VGND.n141 VGND.n5 585
R107 VGND.n11 VGND.n4 585
R108 VGND.n12 VGND.n10 585
R109 VGND.n17 VGND.n14 585
R110 VGND.n23 VGND.n22 585
R111 VGND.n27 VGND.n24 585
R112 VGND.n33 VGND.n32 585
R113 VGND.n37 VGND.n34 585
R114 VGND.n43 VGND.n42 585
R115 VGND.n47 VGND.n44 585
R116 VGND.n53 VGND.n52 585
R117 VGND.n57 VGND.n54 585
R118 VGND.n63 VGND.n62 585
R119 VGND.n67 VGND.n64 585
R120 VGND.n73 VGND.n72 585
R121 VGND.n114 VGND.n71 585
R122 VGND.n116 VGND.n66 585
R123 VGND.n118 VGND.n61 585
R124 VGND.n120 VGND.n56 585
R125 VGND.n122 VGND.n51 585
R126 VGND.n124 VGND.n46 585
R127 VGND.n127 VGND.n41 585
R128 VGND.n129 VGND.n36 585
R129 VGND.n131 VGND.n31 585
R130 VGND.n133 VGND.n26 585
R131 VGND.n135 VGND.n21 585
R132 VGND.n137 VGND.n16 585
R133 VGND.n139 VGND.n9 585
R134 VGND.n11 VGND.n5 390.378
R135 VGND.n112 VGND.n72 137.74
R136 VGND.n114 VGND.n72 140.273
R137 VGND.n114 VGND.n67 140.273
R138 VGND.n116 VGND.n67 140.273
R139 VGND.n116 VGND.n62 140.273
R140 VGND.n118 VGND.n62 140.273
R141 VGND.n118 VGND.n57 140.273
R142 VGND.n120 VGND.n57 140.273
R143 VGND.n120 VGND.n52 140.273
R144 VGND.n122 VGND.n52 140.273
R145 VGND.n122 VGND.n47 140.273
R146 VGND.n124 VGND.n47 140.273
R147 VGND.n124 VGND.n42 140.273
R148 VGND.n127 VGND.n42 140.273
R149 VGND.n127 VGND.n37 140.273
R150 VGND.n129 VGND.n37 140.273
R151 VGND.n129 VGND.n32 140.273
R152 VGND.n131 VGND.n32 140.273
R153 VGND.n131 VGND.n27 140.273
R154 VGND.n133 VGND.n27 140.273
R155 VGND.n133 VGND.n22 140.273
R156 VGND.n135 VGND.n22 140.273
R157 VGND.n135 VGND.n17 140.273
R158 VGND.n137 VGND.n17 140.273
R159 VGND.n137 VGND.n10 140.273
R160 VGND.n139 VGND.n10 140.273
R161 VGND.n139 VGND.n4 140.273
R162 VGND.n141 VGND.n4 135.107
R163 VGND.n126 VGND.n0 48.4779
R164 VGND.n128 VGND.n0 48.4779
R165 VGND.n1 VGND 1.8993
R166 VGND.n90 VGND.n89 1.0345
R167 VGND.n141 VGND.n3 352.086
R168 VGND.n140 VGND.n7 507.332
R169 VGND.n13 VGND.n5 528.249
R170 VGND.n134 VGND.n14 507.332
R171 VGND.n136 VGND.n19 507.332
R172 VGND.n130 VGND.n24 507.332
R173 VGND.n132 VGND.n29 517.321
R174 VGND.n126 VGND.n34 480.139
R175 VGND.n128 VGND.n123 45.6407
R176 VGND.n128 VGND.n39 680.484
R177 VGND.n123 VGND.n39 813.115
R178 VGND.n125 VGND.n44 507.332
R179 VGND.n119 VGND.n49 507.332
R180 VGND.n121 VGND.n54 507.332
R181 VGND.n115 VGND.n59 507.332
R182 VGND.n117 VGND.n64 507.332
R183 VGND.n111 VGND.n69 443.702
R184 VGND.n75 VGND.n9 443.591
R185 VGND.n76 VGND.n16 507.332
R186 VGND.n76 VGND.n21 507.332
R187 VGND.n77 VGND.n26 507.332
R188 VGND.n77 VGND.n31 507.332
R189 VGND.n78 VGND.n36 507.332
R190 VGND.n78 VGND.n41 507.332
R191 VGND.n79 VGND.n46 507.332
R192 VGND.n79 VGND.n51 507.332
R193 VGND.n80 VGND.n56 507.332
R194 VGND.n80 VGND.n61 507.332
R195 VGND.n81 VGND.n66 507.332
R196 VGND.n81 VGND.n71 489.091
R197 VGND.n112 VGND.n83 467.993
R198 VGND.n112 VGND.n84 312.483
R199 VGND.n83 VGND.n84 412.447
R200 VGND.n85 VGND.n110 3932.53
R201 VGND.n85 VGND.n91 4457.68
R202 VGND.n110 VGND.n91 3148.1
R203 VGND.n0 VGND.n90 2.66959
R204 VGND.n0 VGND.n86 125.136
R205 VGND.n90 VGND.n86 80.8221
R206 VGND.n87 VGND.t1 2.59115
R207 VGND.n89 VGND.n87 2.09055
R208 VGND.n89 VGND.n88 97.9893
R209 VGND.n87 VGND.n88 97.9893
R210 VGND.n102 VGND.n8 430.402
R211 VGND.n103 VGND.n15 507.332
R212 VGND.n103 VGND.n20 507.332
R213 VGND.n104 VGND.n25 507.332
R214 VGND.n104 VGND.n30 507.332
R215 VGND.n105 VGND.n35 507.332
R216 VGND.n105 VGND.n40 507.332
R217 VGND.n106 VGND.n45 507.332
R218 VGND.n106 VGND.n50 507.332
R219 VGND.n107 VGND.n55 507.332
R220 VGND.n107 VGND.n60 507.332
R221 VGND.n108 VGND.n65 507.332
R222 VGND.n108 VGND.n70 507.332
R223 VGND.n109 VGND.n74 443.702
R224 VGND.n113 VGND.n73 443.692
R225 VGND.n115 VGND.n68 507.332
R226 VGND.n117 VGND.n63 507.332
R227 VGND.n119 VGND.n58 507.332
R228 VGND.n121 VGND.n53 507.332
R229 VGND.n123 VGND.n48 507.332
R230 VGND.n126 VGND.n125 45.6407
R231 VGND.n126 VGND.n43 680.484
R232 VGND.n125 VGND.n43 813.115
R233 VGND.n128 VGND.n38 480.139
R234 VGND.n130 VGND.n33 517.321
R235 VGND.n132 VGND.n28 507.332
R236 VGND.n134 VGND.n23 507.332
R237 VGND.n136 VGND.n18 507.332
R238 VGND.n138 VGND.n12 507.332
R239 VGND.n140 VGND.n6 368.724
R240 VGND.n2 VGND.n142 934.404
R241 VGND.n2 VGND.n143 505.671
R242 VGND.n142 VGND.n143 519.019
R243 VGND.n9 VGND.n4 1760.11
R244 VGND.n75 VGND.n4 1870.09
R245 VGND.n142 VGND.n5 1113.56
R246 VGND.n142 VGND.n13 176.037
R247 VGND.n5 VGND.n138 1858.52
R248 VGND.n13 VGND.n138 81.3306
R249 VGND.n13 VGND.n11 1858.52
R250 VGND.n138 VGND.n11 620.966
R251 VGND.n9 VGND.n16 1246.43
R252 VGND.n9 VGND.n10 1915.88
R253 VGND.n16 VGND.n10 1915.88
R254 VGND.n16 VGND.n21 1318.72
R255 VGND.n16 VGND.n17 1958
R256 VGND.n21 VGND.n17 1958
R257 VGND.n76 VGND.n17 2907.18
R258 VGND.n21 VGND.n26 1246.43
R259 VGND.n21 VGND.n22 1915.88
R260 VGND.n26 VGND.n22 1915.88
R261 VGND.n26 VGND.n31 1318.72
R262 VGND.n26 VGND.n27 1958
R263 VGND.n31 VGND.n27 1958
R264 VGND.n77 VGND.n27 2907.18
R265 VGND.n31 VGND.n36 1246.43
R266 VGND.n31 VGND.n32 1915.88
R267 VGND.n36 VGND.n32 1915.88
R268 VGND.n36 VGND.n41 1318.72
R269 VGND.n36 VGND.n37 1958
R270 VGND.n41 VGND.n37 1958
R271 VGND.n78 VGND.n37 2907.18
R272 VGND.n41 VGND.n46 1246.43
R273 VGND.n41 VGND.n42 1915.88
R274 VGND.n46 VGND.n42 1915.88
R275 VGND.n46 VGND.n51 1318.72
R276 VGND.n46 VGND.n47 1958
R277 VGND.n51 VGND.n47 1958
R278 VGND.n79 VGND.n47 2907.18
R279 VGND.n51 VGND.n56 1246.43
R280 VGND.n51 VGND.n52 1915.88
R281 VGND.n56 VGND.n52 1915.88
R282 VGND.n56 VGND.n61 1318.72
R283 VGND.n56 VGND.n57 1958
R284 VGND.n61 VGND.n57 1958
R285 VGND.n80 VGND.n57 2907.18
R286 VGND.n61 VGND.n66 1246.43
R287 VGND.n61 VGND.n62 1915.88
R288 VGND.n66 VGND.n62 1915.88
R289 VGND.n66 VGND.n71 1318.72
R290 VGND.n66 VGND.n67 1958
R291 VGND.n71 VGND.n67 1958
R292 VGND.n81 VGND.n67 2907.18
R293 VGND.n71 VGND.n72 1713.93
R294 VGND.n83 VGND.t12 152.672
R295 VGND.n8 VGND.n4 1755.99
R296 VGND.n102 VGND.n4 1720.4
R297 VGND.n8 VGND.n15 1246.43
R298 VGND.n8 VGND.n10 1915.88
R299 VGND.n15 VGND.n10 1915.88
R300 VGND.n15 VGND.n20 1318.72
R301 VGND.n15 VGND.n17 1958
R302 VGND.n20 VGND.n17 1958
R303 VGND.n103 VGND.n17 2907.18
R304 VGND.n20 VGND.n25 1246.43
R305 VGND.n20 VGND.n22 1915.88
R306 VGND.n25 VGND.n22 1915.88
R307 VGND.n25 VGND.n30 1318.72
R308 VGND.n25 VGND.n27 1958
R309 VGND.n30 VGND.n27 1958
R310 VGND.n104 VGND.n27 2907.18
R311 VGND.n30 VGND.n35 1246.43
R312 VGND.n30 VGND.n32 1915.88
R313 VGND.n35 VGND.n32 1915.88
R314 VGND.n35 VGND.n40 1318.72
R315 VGND.n35 VGND.n37 1958
R316 VGND.n40 VGND.n37 1958
R317 VGND.n105 VGND.n37 2907.18
R318 VGND.n40 VGND.n45 1246.43
R319 VGND.n40 VGND.n42 1915.88
R320 VGND.n45 VGND.n42 1915.88
R321 VGND.n45 VGND.n50 1318.72
R322 VGND.n45 VGND.n47 1958
R323 VGND.n50 VGND.n47 1958
R324 VGND.n106 VGND.n47 2907.18
R325 VGND.n50 VGND.n55 1246.43
R326 VGND.n50 VGND.n52 1915.88
R327 VGND.n55 VGND.n52 1915.88
R328 VGND.n55 VGND.n60 1318.72
R329 VGND.n55 VGND.n57 1958
R330 VGND.n60 VGND.n57 1958
R331 VGND.n107 VGND.n57 2907.18
R332 VGND.n60 VGND.n65 1246.43
R333 VGND.n60 VGND.n62 1915.88
R334 VGND.n65 VGND.n62 1915.88
R335 VGND.n65 VGND.n70 1318.72
R336 VGND.n65 VGND.n67 1958
R337 VGND.n70 VGND.n67 1958
R338 VGND.n108 VGND.n67 2907.18
R339 VGND.n70 VGND.n74 1246.43
R340 VGND.n70 VGND.n72 1915.88
R341 VGND.n74 VGND.n72 1915.88
R342 VGND.t11 VGND.n84 152.425
R343 VGND.n73 VGND.n112 1760.43
R344 VGND.n113 VGND.n112 1871.28
R345 VGND.n64 VGND.n73 1246.43
R346 VGND.n64 VGND.n114 1915.88
R347 VGND.n73 VGND.n114 1915.88
R348 VGND.n68 VGND.n69 1246.43
R349 VGND.n68 VGND.n114 1915.88
R350 VGND.n69 VGND.n114 1915.88
R351 VGND.n59 VGND.n68 1318.72
R352 VGND.n59 VGND.n116 1958
R353 VGND.n68 VGND.n116 1958
R354 VGND.n115 VGND.n116 2907.18
R355 VGND.n63 VGND.n64 1318.72
R356 VGND.n63 VGND.n116 1958
R357 VGND.n64 VGND.n116 1958
R358 VGND.n117 VGND.n116 2907.18
R359 VGND.n54 VGND.n63 1246.43
R360 VGND.n54 VGND.n118 1915.88
R361 VGND.n63 VGND.n118 1915.88
R362 VGND.n58 VGND.n59 1246.43
R363 VGND.n58 VGND.n118 1915.88
R364 VGND.n59 VGND.n118 1915.88
R365 VGND.n49 VGND.n58 1318.72
R366 VGND.n49 VGND.n120 1958
R367 VGND.n58 VGND.n120 1958
R368 VGND.n119 VGND.n120 2907.18
R369 VGND.n53 VGND.n54 1318.72
R370 VGND.n53 VGND.n120 1958
R371 VGND.n54 VGND.n120 1958
R372 VGND.n121 VGND.n120 2907.18
R373 VGND.n44 VGND.n53 1246.43
R374 VGND.n44 VGND.n122 1915.88
R375 VGND.n53 VGND.n122 1915.88
R376 VGND.n48 VGND.n49 1246.43
R377 VGND.n48 VGND.n122 1915.88
R378 VGND.n49 VGND.n122 1915.88
R379 VGND.n39 VGND.n48 1318.72
R380 VGND.n39 VGND.n124 1958
R381 VGND.n48 VGND.n124 1958
R382 VGND.n123 VGND.n124 2907.18
R383 VGND.n43 VGND.n44 1318.72
R384 VGND.n43 VGND.n124 1958
R385 VGND.n44 VGND.n124 1958
R386 VGND.n125 VGND.n124 2907.18
R387 VGND.n34 VGND.n43 1318.72
R388 VGND.n34 VGND.n127 1958
R389 VGND.n43 VGND.n127 1958
R390 VGND.n126 VGND.n127 2907.18
R391 VGND.n38 VGND.n39 1318.72
R392 VGND.n38 VGND.n127 1958
R393 VGND.n39 VGND.n127 1958
R394 VGND.n128 VGND.n127 2907.18
R395 VGND.n29 VGND.n38 1256.26
R396 VGND.n29 VGND.n129 1918.39
R397 VGND.n38 VGND.n129 1921.78
R398 VGND.n33 VGND.n34 1256.26
R399 VGND.n33 VGND.n129 1918.39
R400 VGND.n34 VGND.n129 1921.78
R401 VGND.n24 VGND.n33 1318.72
R402 VGND.n24 VGND.n131 1958
R403 VGND.n33 VGND.n131 1958
R404 VGND.n130 VGND.n131 2907.18
R405 VGND.n28 VGND.n29 1318.72
R406 VGND.n28 VGND.n131 1958
R407 VGND.n29 VGND.n131 1958
R408 VGND.n132 VGND.n131 2907.18
R409 VGND.n19 VGND.n28 1246.43
R410 VGND.n19 VGND.n133 1915.88
R411 VGND.n28 VGND.n133 1915.88
R412 VGND.n23 VGND.n24 1246.43
R413 VGND.n23 VGND.n133 1915.88
R414 VGND.n24 VGND.n133 1915.88
R415 VGND.n14 VGND.n23 1318.72
R416 VGND.n14 VGND.n135 1958
R417 VGND.n23 VGND.n135 1958
R418 VGND.n134 VGND.n135 2907.18
R419 VGND.n18 VGND.n19 1318.72
R420 VGND.n18 VGND.n135 1958
R421 VGND.n19 VGND.n135 1958
R422 VGND.n136 VGND.n135 2907.18
R423 VGND.n7 VGND.n18 1246.43
R424 VGND.n7 VGND.n137 1915.88
R425 VGND.n18 VGND.n137 1915.88
R426 VGND.n12 VGND.n14 1246.43
R427 VGND.n12 VGND.n137 1915.88
R428 VGND.n14 VGND.n137 1915.88
R429 VGND.n11 VGND.n12 1318.72
R430 VGND.n11 VGND.n139 1958
R431 VGND.n12 VGND.n139 1958
R432 VGND.n138 VGND.n139 2907.18
R433 VGND.n6 VGND.n7 1318.72
R434 VGND.n6 VGND.n139 1958
R435 VGND.n7 VGND.n139 1958
R436 VGND.n140 VGND.n139 2907.18
R437 VGND.n10 VGND.n76 6276.49
R438 VGND.n10 VGND.n75 6276.49
R439 VGND.n16 VGND.n75 1602.64
R440 VGND.n76 VGND.n9 1602.64
R441 VGND.n76 VGND.n75 112.957
R442 VGND.n22 VGND.n77 6276.49
R443 VGND.n22 VGND.n76 6276.49
R444 VGND.n26 VGND.n76 1602.64
R445 VGND.n77 VGND.n21 1602.64
R446 VGND.n77 VGND.n76 112.957
R447 VGND.n32 VGND.n78 6276.49
R448 VGND.n32 VGND.n77 6276.49
R449 VGND.n36 VGND.n77 1602.64
R450 VGND.n78 VGND.n31 1602.64
R451 VGND.n78 VGND.n77 112.957
R452 VGND.n42 VGND.n79 6276.49
R453 VGND.n42 VGND.n78 6276.49
R454 VGND.n46 VGND.n78 1602.64
R455 VGND.n79 VGND.n41 1602.64
R456 VGND.n79 VGND.n78 112.957
R457 VGND.n52 VGND.n80 6276.49
R458 VGND.n52 VGND.n79 6276.49
R459 VGND.n56 VGND.n79 1602.64
R460 VGND.n80 VGND.n51 1602.64
R461 VGND.n80 VGND.n79 112.957
R462 VGND.n62 VGND.n81 6276.49
R463 VGND.n62 VGND.n80 6276.49
R464 VGND.n66 VGND.n80 1602.64
R465 VGND.n81 VGND.n61 1602.64
R466 VGND.n81 VGND.n80 112.957
R467 VGND.n72 VGND.n82 3011.27
R468 VGND.n72 VGND.n81 4827.29
R469 VGND.n82 VGND.n71 1124.2
R470 VGND.n82 VGND.n81 110.382
R471 VGND.n113 VGND.n2 194.796
R472 VGND.n2 VGND.t12 152.436
R473 VGND.n82 VGND.n83 168.214
R474 VGND.n111 VGND.n84 194.583
R475 VGND.n10 VGND.n103 6276.49
R476 VGND.n10 VGND.n102 6276.49
R477 VGND.n15 VGND.n102 1602.64
R478 VGND.n103 VGND.n8 1602.64
R479 VGND.n103 VGND.n102 112.957
R480 VGND.n22 VGND.n104 6276.49
R481 VGND.n22 VGND.n103 6276.49
R482 VGND.n25 VGND.n103 1602.64
R483 VGND.n104 VGND.n20 1602.64
R484 VGND.n104 VGND.n103 112.957
R485 VGND.n32 VGND.n105 6276.49
R486 VGND.n32 VGND.n104 6276.49
R487 VGND.n35 VGND.n104 1602.64
R488 VGND.n105 VGND.n30 1602.64
R489 VGND.n105 VGND.n104 112.957
R490 VGND.n42 VGND.n106 6276.49
R491 VGND.n42 VGND.n105 6276.49
R492 VGND.n45 VGND.n105 1602.64
R493 VGND.n106 VGND.n40 1602.64
R494 VGND.n106 VGND.n105 112.957
R495 VGND.n52 VGND.n107 6276.49
R496 VGND.n52 VGND.n106 6276.49
R497 VGND.n55 VGND.n106 1602.64
R498 VGND.n107 VGND.n50 1602.64
R499 VGND.n107 VGND.n106 112.957
R500 VGND.n62 VGND.n108 6276.49
R501 VGND.n62 VGND.n107 6276.49
R502 VGND.n65 VGND.n107 1602.64
R503 VGND.n108 VGND.n60 1602.64
R504 VGND.n108 VGND.n107 112.957
R505 VGND.n72 VGND.n109 6276.49
R506 VGND.n72 VGND.n108 6276.49
R507 VGND.n74 VGND.n108 1602.64
R508 VGND.n109 VGND.n70 1602.64
R509 VGND.n109 VGND.n108 112.957
R510 VGND.n109 VGND.n110 177.064
R511 VGND.n74 VGND.n110 1113.28
R512 VGND.n110 VGND.t11 152.657
R513 VGND.n114 VGND.n113 6276.49
R514 VGND.n114 VGND.n117 6276.49
R515 VGND.n73 VGND.n117 1602.64
R516 VGND.n113 VGND.n64 1602.64
R517 VGND.n113 VGND.n117 112.957
R518 VGND.n114 VGND.n115 6276.49
R519 VGND.n114 VGND.n111 6276.49
R520 VGND.n68 VGND.n111 1602.64
R521 VGND.n115 VGND.n69 1602.64
R522 VGND.n115 VGND.n111 112.957
R523 VGND.n118 VGND.n117 6276.49
R524 VGND.n118 VGND.n121 6276.49
R525 VGND.n63 VGND.n121 1602.64
R526 VGND.n117 VGND.n54 1602.64
R527 VGND.n117 VGND.n121 112.957
R528 VGND.n118 VGND.n119 6276.49
R529 VGND.n118 VGND.n115 6276.49
R530 VGND.n58 VGND.n115 1602.64
R531 VGND.n119 VGND.n59 1602.64
R532 VGND.n119 VGND.n115 112.957
R533 VGND.n122 VGND.n121 6276.49
R534 VGND.n122 VGND.n125 6276.49
R535 VGND.n53 VGND.n125 1602.64
R536 VGND.n121 VGND.n44 1602.64
R537 VGND.n121 VGND.n125 112.957
R538 VGND.n122 VGND.n123 6276.49
R539 VGND.n122 VGND.n119 6276.49
R540 VGND.n48 VGND.n119 1602.64
R541 VGND.n123 VGND.n49 1602.64
R542 VGND.n123 VGND.n119 112.957
R543 VGND.n129 VGND.n128 5830.75
R544 VGND.n129 VGND.n132 6684.16
R545 VGND.n38 VGND.n132 1869.5
R546 VGND.n128 VGND.n29 1488.83
R547 VGND.n128 VGND.n132 104.936
R548 VGND.n129 VGND.n130 6684.16
R549 VGND.n129 VGND.n126 5830.75
R550 VGND.n33 VGND.n126 1488.83
R551 VGND.n130 VGND.n34 1869.5
R552 VGND.n130 VGND.n126 104.936
R553 VGND.n133 VGND.n132 6276.49
R554 VGND.n133 VGND.n136 6276.49
R555 VGND.n28 VGND.n136 1602.64
R556 VGND.n132 VGND.n19 1602.64
R557 VGND.n132 VGND.n136 112.957
R558 VGND.n133 VGND.n134 6276.49
R559 VGND.n133 VGND.n130 6276.49
R560 VGND.n23 VGND.n130 1602.64
R561 VGND.n134 VGND.n24 1602.64
R562 VGND.n134 VGND.n130 112.957
R563 VGND.n137 VGND.n136 6276.49
R564 VGND.n137 VGND.n140 6276.49
R565 VGND.n18 VGND.n140 1602.64
R566 VGND.n136 VGND.n7 1602.64
R567 VGND.n136 VGND.n140 112.957
R568 VGND.n137 VGND.n138 6276.49
R569 VGND.n137 VGND.n134 6276.49
R570 VGND.n12 VGND.n134 1602.64
R571 VGND.n138 VGND.n14 1602.64
R572 VGND.n138 VGND.n134 112.957
R573 VGND.n75 VGND.n3 219.611
R574 VGND.n145 VGND.n1 130.188
R575 VGND.n112 VGND.n2 4481.54
R576 VGND.n73 VGND.n2 3018.33
R577 VGND.n140 VGND.n141 715.662
R578 VGND.n6 VGND.n141 1287.7
R579 VGND.n145 VGND.t0 227.607
R580 VGND.n144 VGND.t16 234.905
R581 VGND.t13 VGND.n143 39.5034
R582 VGND.n93 VGND.n88 1690.56
R583 VGND.n144 VGND.t15 41.1412
R584 VGND.n145 VGND.t17 38.8292
R585 VGND.n100 VGND.t9 1789.6
R586 VGND.t1 VGND.t4 307.567
R587 VGND.n102 VGND.n101 2223.18
R588 VGND.n95 VGND.t3 3128.1
R589 VGND.n94 VGND.t8 3137.56
R590 VGND.n88 VGND.t7 238.959
R591 VGND.n93 VGND.t7 4474.34
R592 VGND.n92 VGND.t5 3137.56
R593 VGND VGND.t18 165.524
R594 VGND.n145 VGND 7475.59
R595 VGND.t0 VGND 193.668
R596 VGND.t17 VGND.n1 1488.37
R597 VGND.n144 VGND.n1 229.344
R598 VGND.t16 VGND.n1 186.582
R599 VGND.t6 VGND.t1 284.459
R600 VGND.n96 VGND.n95 14230.2
R601 VGND.n96 VGND.t3 3128.1
R602 VGND.n97 VGND.n94 35794.8
R603 VGND.n97 VGND.t8 3137.57
R604 VGND.n97 VGND.n87 2130.48
R605 VGND.t8 VGND.n87 301.142
R606 VGND.n94 VGND.n87 2130.48
R607 VGND.n88 VGND.n98 1690.57
R608 VGND.n98 VGND.n93 69072.5
R609 VGND.n98 VGND.t7 4474.34
R610 VGND.n99 VGND.n92 35794.8
R611 VGND.n99 VGND.t5 3137.57
R612 VGND.n99 VGND.n89 2130.48
R613 VGND.t5 VGND.n89 301.142
R614 VGND.n92 VGND.n89 2130.48
R615 VGND.n101 VGND.n141 7600.92
R616 VGND.n101 VGND.n6 48310.5
R617 VGND.n101 VGND.n140 8172.47
R618 VGND.n102 VGND.n141 754.01
R619 VGND.n102 VGND.n6 9113.45
R620 VGND.n102 VGND.n140 1539.93
R621 VGND.t19 VGND 164.833
R622 VGND.n140 VGND.n4 77070.4
R623 VGND.n140 VGND.n8 51907.2
R624 VGND.n101 VGND.n4 107824
R625 VGND.n101 VGND.n8 72619.8
R626 VGND.n8 VGND.n141 4706.74
R627 VGND.t13 VGND.n0 384.966
R628 VGND.n143 VGND.n0 2268.77
R629 VGND.n101 VGND.n86 2658.95
R630 VGND.n85 VGND.n86 504.337
R631 VGND.t6 VGND.t4 31235.2
R632 VGND.t6 VGND.n95 6662.42
R633 VGND.t4 VGND.n95 23190.2
R634 VGND.t1 VGND.n95 2234.58
R635 VGND.t6 VGND.n96 6753.8
R636 VGND.t4 VGND.n96 23964.8
R637 VGND.t1 VGND.n96 2256.03
R638 VGND.n8 VGND.n3 88870.8
R639 VGND.n101 VGND.n3 13977.8
R640 VGND.n102 VGND.n3 2641.21
R641 VGND.n6 VGND.n3 8318.92
R642 VGND.n140 VGND.n3 1444.99
R643 VGND.n0 VGND.t14 511.363
R644 VGND.n143 VGND.t14 2277.84
R645 VGND.t13 VGND.t14 384.534
R646 VGND.n144 VGND.t17 22352
R647 VGND.n145 VGND.t16 2224.64
R648 VGND.t16 VGND.t17 364.087
R649 VGND.t0 VGND.t18 341.272
R650 VGND.n145 VGND.t18 13518.7
R651 VGND.t0 VGND.t19 22016.7
R652 VGND.t18 VGND.t19 340.188
R653 VGND.t9 VGND.n90 338.414
R654 VGND.n100 VGND.n90 1044.49
R655 VGND.n86 VGND.t10 256.252
R656 VGND.n85 VGND.t10 1666.61
R657 VGND.t10 VGND.n101 8786.63
R658 VGND.n85 VGND.n101 27372.8
R659 VGND.n96 VGND.n87 3561.26
R660 VGND.t3 VGND.t1 754.5
R661 VGND.t3 VGND.n87 503.38
R662 VGND.n95 VGND.n87 3561.26
R663 VGND.n91 VGND.t9 1789.6
R664 VGND.n90 VGND.n91 1044.49
R665 VGND.n91 VGND.n100 7377.61
R666 VGND.n142 VGND.n3 220.609
R667 VGND.n75 VGND.n142 9962.37
R668 VGND.n75 VGND.n13 166712
R669 VGND.n13 VGND.n3 7281.52
R670 VGND.n110 VGND.n84 739.953
R671 VGND.n84 VGND.n69 3028.97
R672 VGND.n69 VGND.n112 1760.37
R673 VGND.n111 VGND.n112 1871.41
R674 VGND VGND.t2 150.248
R675 VGND.t18 VGND.t2 19453.7
R676 VGND.t2 VGND.t19 335.587
R677 VGND.n83 VGND.n81 12155.9
R678 VGND.n83 VGND.n72 14531.8
R679 VGND.n83 VGND.n71 9454.12
R680 VGND.n81 VGND.n112 6383.79
R681 VGND.n71 VGND.n112 4964.91
R682 VGND.n82 VGND.n112 1767.27
R683 VGND.n82 VGND.n2 9646.22
R684 VGND.n82 VGND.t12 13537
R685 VGND.n83 VGND.n2 740.087
R686 VGND.t13 VGND.n144 64739.2
R687 VGND.t13 VGND.t15 22278.2
R688 VGND.n143 VGND.t15 131906
R689 VGND.n144 VGND.t14 3461.87
R690 VGND.t14 VGND.t15 373.509
R691 VGND.n143 VGND.n1 3093.34
R692 VGND.t13 VGND.n1 524.822
R693 VGND.t14 VGND.n1 247.877
R694 VGND.t15 VGND.n0 1584.63
R695 VGND.t15 VGND.n1 645.422
R696 VGND.n144 VGND.n0 603.226
R697 VGND.n0 VGND.n1 3.6176
R698 VGND.n83 VGND.n113 11352.8
R699 VGND.n82 VGND.n113 146465
R700 VGND.n113 VGND.t12 14802.8
R701 VGND.n111 VGND.n109 146489
R702 VGND.n111 VGND.n110 11373
R703 VGND.n111 VGND.t11 16082.1
R704 VGND.n109 VGND.t11 17870.5
R705 VGND.n109 VGND.n84 9769.47
R706 VGND.n3 VGND.n4 10590.2
R707 VGND.n3 VGND.n9 7132.56
R708 VGND.n9 VGND.n141 5203.09
R709 VGND.n75 VGND.n141 1566.24
R710 VDPWR.n1 VDPWR.t0 97.7067
R711 VDPWR.n2 VDPWR.t10 88.6768
R712 VDPWR.n3 VDPWR.t2 88.6768
R713 VDPWR.n4 VDPWR.t4 88.6768
R714 VDPWR.n1 VDPWR.t14 47.077
R715 VDPWR.n1 VDPWR.t16 47.077
R716 VDPWR VDPWR.n0 4.42849
R717 VDPWR.n0 VDPWR.n8 2.11844
R718 VDPWR.n1 VDPWR.n2 5.26925
R719 VDPWR.n1 VDPWR.t6 451.851
R720 VDPWR.n2 VDPWR.t6 111.615
R721 VDPWR.n2 VDPWR.n3 2.08056
R722 VDPWR.n2 VDPWR.t12 178.387
R723 VDPWR.n3 VDPWR.t12 178.387
R724 VDPWR.n3 VDPWR.n4 2.08056
R725 VDPWR.n3 VDPWR.t8 178.387
R726 VDPWR.n4 VDPWR.t8 178.387
R727 VDPWR.n5 VDPWR.n4 14.6442
R728 VDPWR.n6 VDPWR.n5 2.07547
R729 VDPWR.n7 VDPWR.n6 2.07547
R730 VDPWR.n8 VDPWR.n7 2.07606
R731 VDPWR.t3 VDPWR.n4 2173.77
R732 VDPWR.t3 VDPWR.n5 166.266
R733 VDPWR.t1 VDPWR.n5 308.015
R734 VDPWR.t1 VDPWR.n6 308.015
R735 VDPWR.t9 VDPWR.n6 308.015
R736 VDPWR.t9 VDPWR.n7 308.015
R737 VDPWR.t17 VDPWR.n7 283.887
R738 VDPWR.t17 VDPWR.n8 283.887
R739 VDPWR.t15 VDPWR.n0 148.292
R740 VDPWR.t13 VDPWR.n0 148.292
R741 VDPWR.n5 VDPWR.t7 153.492
R742 VDPWR.n6 VDPWR.t11 153.492
R743 VDPWR.n7 VDPWR.t5 153.492
R744 VDPWR.n8 VDPWR.t18 141.428
C0 xtp_xn.S.t1 xtn_xn.S.t1 30.8956f
C1 xtp_xn.S.t1 xn1.S.t0 0.20755f
C2 xtp_xn.S.t1 xn1.D.n0 0.28832f
C3 xtp_xn.S.t1 xis_xn.G.n0 0.28344f
C4 xtp_xn.S.t1 xis_xn.D.n0 0.28337f
C5 xtp_xn.S.t1 xib_xn.D.n0 0.46518f
C6 xtp_xn.S.t1 xi1_xn.D.n0 7.65263f
C7 xtp_xn.S.t1 xi0_xn.D.n0 0.72894f
C8 xtp_xn.S.t1 xbuf_xn.D.n0 0.28309f
C9 xtp_xn.S.t1 xrbp.R2 0.49321f
C10 xtp_xn.S.t1 VDPWR 1.3874f
C11 xtp_xn.S.t1 rxn 0.24796f
C12 xtp_xn.S.t1 din 0.30848f
C13 xtp_xn.S.t1 boost 30.7624f
C14 xtp_xn.S.t1 dout 0.23831f
C15 xtp_xn.S.t1 rxp 0.2477f
C16 xtp_xn.S.t1 txp 0.49616f
C17 xtp_xn.S.t1 txn 0.20755f
C18 xtn_xn.S.t1 xn1.S.t0 0.38684f
C19 xtn_xn.S.t1 xn1.D.n0 0.78938f
C20 xtn_xn.S.t1 xis_xn.G.n0 0.294f
C21 xtn_xn.S.t1 xis_xn.D.n0 0.29364f
C22 xtn_xn.S.t1 xib_xn.D.n0 0.47094f
C23 xtn_xn.S.t1 xi1_xn.D.n0 0.21184f
C24 xtn_xn.S.t1 xi0_xn.D.n0 8.02904f
C25 xtn_xn.S.t1 xbuf_xn.D.n0 0.29364f
C26 xtn_xn.S.t1 xrbp.R2 0.23252f
C27 xtn_xn.S.t1 VDPWR 1.44088f
C28 xtn_xn.S.t1 rxn 0.25418f
C29 xtn_xn.S.t1 din 0.3187f
C30 xtn_xn.S.t1 boost 0.50754f
C31 xtn_xn.S.t1 dout 0.20859f
C32 xtn_xn.S.t1 rxp 0.25385f
C33 xtn_xn.S.t1 txp 0.30528f
C34 xtn_xn.S.t1 txn 0.52455f
C35 xn1.S.t0 xn1.D.n0 2.94679f
C36 xn1.S.t0 xis_xn.G.n0 3.10964f
C37 xn1.S.t0 xis_xn.D.n0 0.18696f
C38 xn1.S.t0 xib_xn.D.n0 0.18484f
C39 xn1.S.t0 xi1_xn.D.n0 0.29814f
C40 xn1.S.t0 xi0_xn.D.n0 0.33477f
C41 xn1.S.t0 xbuf_xn.D.n0 0.18873f
C42 xn1.S.t0 xrbp.R2 0.27355f
C43 xn1.S.t0 VDPWR 0.76156f
C44 xn1.S.t0 rxn 1.56206f
C45 xn1.S.t0 din 0.12112f
C46 xn1.S.t0 boost 0.09511f
C47 xn1.S.t0 dout 0.18518f
C48 xn1.S.t0 rxp 31.8307f
C49 xn1.S.t0 txp 0.22555f
C50 xn1.S.t0 txn 30.6107f
C51 xn1.D.n0 xis_xn.G.n0 31.4397f
C52 xn1.D.n0 xis_xn.D.n0 0.26898f
C53 xn1.D.n0 xib_xn.D.n0 0.27703f
C54 xn1.D.n0 xi1_xn.D.n0 30.6596f
C55 xn1.D.n0 xi0_xn.D.n0 0.41447f
C56 xn1.D.n0 xbuf_xn.D.n0 0.26391f
C57 xn1.D.n0 xrbp.R2 0.35514f
C58 xn1.D.n0 VDPWR 7.78234f
C59 xn1.D.n0 rxn 1.68619f
C60 xn1.D.n0 din 0.19983f
C61 xn1.D.n0 boost 0.17624f
C62 xn1.D.n0 dout 0.27312f
C63 xn1.D.n0 rxp 0.22576f
C64 xn1.D.n0 txp 0.18049f
C65 xn1.D.n0 txn 0.18066f
C66 xis_xn.G.n0 xis_xn.D.n0 30.7151f
C67 xis_xn.G.n0 xib_xn.D.n0 0.26181f
C68 xis_xn.G.n0 xi1_xn.D.n0 0.45119f
C69 xis_xn.G.n0 xi0_xn.D.n0 0.41728f
C70 xis_xn.G.n0 xbuf_xn.D.n0 0.26946f
C71 xis_xn.G.n0 xrbp.R2 0.34997f
C72 xis_xn.G.n0 VDPWR 5.89983f
C73 xis_xn.G.n0 rxn 0.22831f
C74 xis_xn.G.n0 din 0.20267f
C75 xis_xn.G.n0 boost 0.1713f
C76 xis_xn.G.n0 dout 0.26424f
C77 xis_xn.G.n0 rxp 1.68635f
C78 xis_xn.G.n0 txp 0.1812f
C79 xis_xn.G.n0 txn 0.18132f
C80 xis_xn.D.n0 xib_xn.D.n0 0.32227f
C81 xis_xn.D.n0 xi1_xn.D.n0 0.37677f
C82 xis_xn.D.n0 xi0_xn.D.n0 0.42762f
C83 xis_xn.D.n0 xbuf_xn.D.n0 30.7677f
C84 xis_xn.D.n0 xrbp.R2 0.34973f
C85 xis_xn.D.n0 VDPWR 5.99537f
C86 xis_xn.D.n0 rxn 0.23204f
C87 xis_xn.D.n0 din 0.2123f
C88 xis_xn.D.n0 boost 0.17118f
C89 xis_xn.D.n0 dout 0.26288f
C90 xis_xn.D.n0 rxp 0.22795f
C91 xis_xn.D.n0 txp 0.18571f
C92 xis_xn.D.n0 txn 0.18614f
C93 xib_xn.D.n0 xi1_xn.D.n0 0.42572f
C94 xib_xn.D.n0 xi0_xn.D.n0 0.4244f
C95 xib_xn.D.n0 xbuf_xn.D.n0 0.26071f
C96 xib_xn.D.n0 xrbp.R2 30.4708f
C97 xib_xn.D.n0 VDPWR 6.31161f
C98 xib_xn.D.n0 rxn 0.2255f
C99 xib_xn.D.n0 din 0.27476f
C100 xib_xn.D.n0 boost 30.6283f
C101 xib_xn.D.n0 dout 0.18817f
C102 xib_xn.D.n0 rxp 0.22491f
C103 xib_xn.D.n0 txp 0.18475f
C104 xib_xn.D.n0 txn 0.18475f
C105 xi1_xn.D.n0 xi0_xn.D.n0 0.87256f
C106 xi1_xn.D.n0 xbuf_xn.D.n0 0.37513f
C107 xi1_xn.D.n0 xrbp.R2 0.27619f
C108 xi1_xn.D.n0 VDPWR 5.56119f
C109 xi1_xn.D.n0 rxn 0.33884f
C110 xi1_xn.D.n0 din 0.11606f
C111 xi1_xn.D.n0 boost 0.2018f
C112 xi1_xn.D.n0 dout 30.555f
C113 xi1_xn.D.n0 rxp 0.3383f
C114 xi1_xn.D.n0 txp 0.58653f
C115 xi1_xn.D.n0 txn 0.298f
C116 xi0_xn.D.n0 xbuf_xn.D.n0 0.49003f
C117 xi0_xn.D.n0 xrbp.R2 0.43782f
C118 xi0_xn.D.n0 VDPWR 6.33042f
C119 xi0_xn.D.n0 rxn 0.37459f
C120 xi0_xn.D.n0 din 30.6505f
C121 xi0_xn.D.n0 boost 0.28037f
C122 xi0_xn.D.n0 dout 30.5999f
C123 xi0_xn.D.n0 rxp 0.36766f
C124 xi0_xn.D.n0 txp 0.64808f
C125 xi0_xn.D.n0 txn 0.66206f
C126 xbuf_xn.D.n0 xrbp.R2 0.34958f
C127 xbuf_xn.D.n0 VDPWR 6.05555f
C128 xbuf_xn.D.n0 rxn 30.4998f
C129 xbuf_xn.D.n0 din 0.2573f
C130 xbuf_xn.D.n0 boost 0.18173f
C131 xbuf_xn.D.n0 dout 0.48688f
C132 xbuf_xn.D.n0 rxp 0.23179f
C133 xbuf_xn.D.n0 txp 0.18614f
C134 xbuf_xn.D.n0 txn 0.18696f
C135 xrbp.R2 VDPWR 1.52223f
C136 xrbp.R2 rxn 0.31425f
C137 xrbp.R2 din 30.6298f
C138 xrbp.R2 boost 0.10581f
C139 xrbp.R2 dout 0.2768f
C140 xrbp.R2 rxp 0.31394f
C141 xrbp.R2 txp 1.07387f
C142 xrbp.R2 txn 1.43265f
C143 VDPWR rxn 0.8294f
C144 VDPWR din 2.1822f
C145 VDPWR boost 2.7403f
C146 VDPWR dout 3.77932f
C147 VDPWR rxp 0.55399f
C148 VDPWR txp 31.0258f
C149 VDPWR txn 0.71754f
C150 rxn din 0.222f
C151 rxn boost 0.13552f
C152 rxn dout 0.22571f
C153 rxn rxp 30.4151f
C154 rxn txp 0.09687f
C155 rxn txn 0.0983f
C156 din boost 0.1753f
C157 din dout 0.11447f
C158 din rxp 0.15466f
C159 din txp 0.13829f
C160 din txn 0.12957f
C161 boost dout 0.09649f
C162 boost rxp 0.13526f
C163 boost txp 0.09511f
C164 boost txn 0.09511f
C165 dout rxp 0.22531f
C166 dout txp 0.18502f
C167 dout txn 0.18509f
C168 rxp txp 0.0983f
C169 rxp txn 0.10233f
C170 txp txn 30.7065f
C171 txn VGND 3.26075f
C172 txp VGND 3.19431f
C173 rxp VGND 5.69337f
C174 dout VGND 6.60312f
C175 boost VGND 0.9687f
C176 din VGND 7.44129f
C177 rxn VGND 5.39394f
C178 VDPWR VGND 1.3687f
C179 xrbp.R2 VGND 13.0169f
C180 VDPWR.n0 VGND 11.3686f
C181 VDPWR.n1 VGND 6.59136f
C182 VDPWR.t0 VGND 0.45285f
C183 VDPWR.t14 VGND 1.17457f
C184 VDPWR.t16 VGND 1.17457f
C185 VDPWR.t6 VGND 0.36056f
C186 VDPWR.t10 VGND 0.34219f
C187 VDPWR.n2 VGND 3.42544f
C188 VDPWR.t12 VGND 0.34935f
C189 VDPWR.t2 VGND 0.34219f
C190 VDPWR.n3 VGND 2.4644f
C191 VDPWR.t8 VGND 0.34935f
C192 VDPWR.t4 VGND 0.34219f
C193 VDPWR.n4 VGND 4.76219f
C194 VDPWR.t3 VGND 2.46685f
C195 VDPWR.t7 VGND 2.43826f
C196 VDPWR.n5 VGND 7.241f
C197 VDPWR.t1 VGND 2.44498f
C198 VDPWR.t11 VGND 2.43826f
C199 VDPWR.n6 VGND 3.99381f
C200 VDPWR.t9 VGND 2.44498f
C201 VDPWR.t5 VGND 2.43826f
C202 VDPWR.n7 VGND 4.05196f
C203 VDPWR.t17 VGND 4.18763f
C204 VDPWR.t18 VGND 4.17992f
C205 VDPWR.n8 VGND 3.33321f
C206 VDPWR.t15 VGND 4.99244f
C207 VDPWR.t13 VGND 4.99244f
C208 boost.t1 VGND 0.06438f
C209 boost.t0 VGND 7.71339f
C210 boost.t2 VGND 0.89917f
C211 boost.t3 VGND 1.35264f
C212 din.t0 VGND 0.18978f
C213 din.t1 VGND 0.14164f
C214 dout.t0 VGND 1.34606f
C215 dout.t1 VGND 0.96973f
C216 rxn.t0 VGND 0.82695f
C217 rxp.t0 VGND 0.86844f
C218 txn.n0 VGND 4.29944f
C219 txn.t2 VGND 0.07801f
C220 txn.t1 VGND 0.10526f
C221 txn.t0 VGND 0.06508f
C222 txp.n0 VGND 4.29816f
C223 txp.t2 VGND 0.0789f
C224 txp.t1 VGND 0.10257f
C225 txp.t0 VGND 0.0632f
C226 xbuf_xn.D.t3 VGND 0.21394f
C227 xbuf_xn.D.t2 VGND 0.27886f
C228 xbuf_xn.D.t1 VGND 0.08226f
C229 xbuf_xn.D.n0 VGND 11.7261f
C230 xbuf_xn.D.t0 VGND 0.20441f
C231 xi0_xn.D.n0 VGND 11.3859f
C232 xi0_xn.D.n1 VGND 5.37817f
C233 xi0_xn.D.t0 VGND 0.38999f
C234 xi0_xn.D.t6 VGND 0.21963f
C235 xi0_xn.D.t5 VGND 0.26968f
C236 xi0_xn.D.t2 VGND 0.12399f
C237 xi0_xn.D.t3 VGND 0.26488f
C238 xi0_xn.D.t1 VGND 0.36484f
C239 xi0_xn.D.t4 VGND 0.55022f
C240 xi1_xn.D.n0 VGND 12.1488f
C241 xi1_xn.D.t0 VGND 0.3205f
C242 xi1_xn.D.t2 VGND 0.44587f
C243 xi1_xn.D.t3 VGND 0.63147f
C244 xi1_xn.D.t1 VGND 0.28176f
C245 xi1_xn.D.t4 VGND 0.42858f
C246 xib_xn.D.t3 VGND 0.16602f
C247 xib_xn.D.t2 VGND 0.16469f
C248 xib_xn.D.t0 VGND 0.09132f
C249 xib_xn.D.n0 VGND 10.4908f
C250 xib_xn.D.t1 VGND 0.20755f
C251 xis_xn.D.t3 VGND 0.20299f
C252 xis_xn.D.t2 VGND 0.26128f
C253 xis_xn.D.t1 VGND 0.0846f
C254 xis_xn.D.n0 VGND 11.7629f
C255 xis_xn.D.t0 VGND 0.20919f
C256 xis_xn.G.t1 VGND 0.55004f
C257 xis_xn.G.t3 VGND 0.20686f
C258 xis_xn.G.t2 VGND 0.27767f
C259 xis_xn.G.n0 VGND 10.3965f
C260 xis_xn.G.t0 VGND 0.35024f
C261 xn1.D.t2 VGND 0.42656f
C262 xn1.D.t3 VGND 0.83996f
C263 xn1.D.t1 VGND 0.83877f
C264 xn1.D.n0 VGND 7.91473f
C265 xn1.D.t0 VGND 0.27318f
C266 xn1.S.t0 VGND 4.85388f
C267 xn1.S.t2 VGND 4.33431f
C268 xn1.S.t1 VGND 4.35831f
C269 xtn_xn.S.t0 VGND 5.22232f
C270 xtn_xn.S.t1 VGND 9.29777f
C271 xtn_xn.S.t2 VGND 8.56661f
C272 xtp_xn.S.t0 VGND 2.45626f
C273 xtp_xn.S.t1 VGND 4.38266f
C274 xtp_xn.S.t2 VGND 4.03448f
.ends
