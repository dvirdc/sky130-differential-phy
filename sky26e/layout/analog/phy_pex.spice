* NGSPICE file created from phy_pex.ext - technology: sky130A

.subckt phy_pex din boost rxp rxn txp txn dout VDPWR VGND
X0 VDPWR.t10 xis_xn.D.t3 xbuf_xn.D.t0 VDPWR.t9 sky130_fd_pr__pfet_01v8 ad=1.16 pd=8.58 as=1.16 ps=8.58 w=4 l=0.15
X1 VDPWR.t12 xis_xn.G.t3 xis_xn.D.t0 VDPWR.t11 sky130_fd_pr__pfet_01v8 ad=1.16 pd=8.58 as=1.16 ps=8.58 w=4 l=0.15
X2 txp.t1 xrbp.R2 VGND.t15 sky130_fd_pr__res_high_po_0p35 l=1
X3 xrbp.R2 VGND.t1 VGND.t0 sky130_fd_pr__res_high_po_0p35 l=20
X4 VGND.t1 boost.t0 xib_xn.D.t0 VGND.t3 sky130_fd_pr__nfet_01v8 ad=0.58 pd=4.58 as=0.58 ps=4.58 w=2 l=0.15
X5 VGND.t1 xi0_xn.D.t5 xi1_xn.D.t2 VGND.t6 sky130_fd_pr__nfet_01v8 ad=0.58 pd=4.58 as=0.58 ps=4.58 w=2 l=0.15
X6 VDPWR.t6 xbuf_xn.D.t3 dout.t0 VDPWR.t5 sky130_fd_pr__pfet_01v8 ad=1.16 pd=8.58 as=1.16 ps=8.58 w=4 l=0.15
X7 xn1.S.t2 rxp.t0 xis_xn.G.t0 VGND.t12 sky130_fd_pr__nfet_01v8 ad=6.96 pd=48.58 as=6.96 ps=48.58 w=24 l=1
X8 xn1.S.t1 rxn.t0 xn1.D.t0 VGND.t11 sky130_fd_pr__nfet_01v8 ad=6.96 pd=48.58 as=6.96 ps=48.58 w=24 l=1
X9 xn1.S.t0 VGND.t1 VGND.t2 sky130_fd_pr__res_high_po_0p35 l=20
X10 VDPWR.t16 xn1.D.t1 xn1.D.t2 VDPWR.t15 sky130_fd_pr__pfet_01v8 ad=3.48 pd=24.58 as=3.48 ps=24.58 w=12 l=1
X11 xtp_xn.S.t0 txp.t2 VGND.t18 sky130_fd_pr__res_high_po_0p35 l=28
X12 VGND.t1 xbuf_xn.D.t2 dout.t1 VGND.t5 sky130_fd_pr__nfet_01v8 ad=0.58 pd=4.58 as=0.58 ps=4.58 w=2 l=0.15
X13 VDPWR.t2 boost.t1 xib_xn.D.t1 VDPWR.t1 sky130_fd_pr__pfet_01v8 ad=1.16 pd=8.58 as=1.16 ps=8.58 w=4 l=0.15
X14 VGND.t1 xis_xn.D.t2 xbuf_xn.D.t1 VGND.t7 sky130_fd_pr__nfet_01v8 ad=0.58 pd=4.58 as=0.58 ps=4.58 w=2 l=0.15
X15 VDPWR.t8 xi0_xn.D.t6 xi1_xn.D.t3 VDPWR.t7 sky130_fd_pr__pfet_01v8 ad=1.16 pd=8.58 as=1.16 ps=8.58 w=4 l=0.15
X16 VGND.t1 xis_xn.G.t2 xis_xn.D.t1 VGND.t8 sky130_fd_pr__nfet_01v8 ad=0.58 pd=4.58 as=0.58 ps=4.58 w=2 l=0.15
X17 VDPWR.t4 din.t1 xi0_xn.D.t3 VDPWR.t3 sky130_fd_pr__pfet_01v8 ad=1.16 pd=8.58 as=1.16 ps=8.58 w=4 l=0.15
X18 VDPWR.t0 xrbp.R2 VGND.t17 sky130_fd_pr__res_high_po_0p35 l=20
X19 xi0_xn.D.t0 txn.t0 VGND.t14 sky130_fd_pr__res_high_po_0p35 l=28
X20 xtn_xn.S.t0 txn.t2 VGND.t19 sky130_fd_pr__res_high_po_0p35 l=28
X21 xtn_xn.S.t2 xib_xn.D.t3 xi0_xn.D.t4 VDPWR.t18 sky130_fd_pr__pfet_01v8 ad=2.32 pd=16.58 as=2.32 ps=16.58 w=8 l=0.15
X22 VDPWR.t14 xn1.D.t3 xis_xn.G.t1 VDPWR.t13 sky130_fd_pr__pfet_01v8 ad=3.48 pd=24.58 as=3.48 ps=24.58 w=12 l=1
X23 xtp_xn.S.t2 xib_xn.D.t2 xi1_xn.D.t4 VDPWR.t17 sky130_fd_pr__pfet_01v8 ad=2.32 pd=16.58 as=2.32 ps=16.58 w=8 l=0.15
X24 xtn_xn.S.t1 boost.t3 xi0_xn.D.t1 VGND.t10 sky130_fd_pr__nfet_01v8 ad=1.16 pd=8.58 as=1.16 ps=8.58 w=4 l=0.15
X25 xi1_xn.D.t0 txp.t0 VGND.t13 sky130_fd_pr__res_high_po_0p35 l=28
X26 VGND.t1 din.t0 xi0_xn.D.t2 VGND.t4 sky130_fd_pr__nfet_01v8 ad=0.58 pd=4.58 as=0.58 ps=4.58 w=2 l=0.15
X27 txn.t1 xrbp.R2 VGND.t16 sky130_fd_pr__res_high_po_0p35 l=1
X28 xtp_xn.S.t1 boost.t2 xi1_xn.D.t1 VGND.t9 sky130_fd_pr__nfet_01v8 ad=1.16 pd=8.58 as=1.16 ps=8.58 w=4 l=0.15
R0 xtp_xn.S.t0 xtp_xn.S.t1 367.358
R1 xtp_xn.S.t0 xtp_xn.S.t2 395.457
R2 xtp_xn.S.t1 xtp_xn.S.t2 232.982
R3 xtn_xn.S.t0 xtn_xn.S.t1 369.978
R4 xtn_xn.S.t0 xtn_xn.S.t2 397.815
R5 xtn_xn.S.t1 xtn_xn.S.t2 237.394
R6 xn1.S.t0 xn1.S.t1 375.277
R7 xn1.S.t0 xn1.S.t2 372.767
R8 xn1.S.t1 xn1.S.t2 413.072
R9 xn1.D.t0 xn1.D.n0 141.185
R10 xn1.D.n0 xn1.D.t2 72.9701
R11 xn1.D.t3 xn1.D.n0 519.874
R12 xn1.D.t3 xn1.D.t1 4642.87
R13 xn1.D.n0 xn1.D.t1 518.78
R14 xis_xn.G.t0 xis_xn.G.n0 139.756
R15 xis_xn.G.n0 xis_xn.G.t1 71.5415
R16 xis_xn.G.t3 xis_xn.G.n0 1024.67
R17 xis_xn.G.t3 xis_xn.G.t2 16311.1
R18 xis_xn.G.n0 xis_xn.G.t2 654.36
R19 xis_xn.D.n0 xis_xn.D.t1 140.923
R20 xis_xn.D.t0 xis_xn.D.n0 110.82
R21 xis_xn.D.t3 xis_xn.D.n0 1004.6
R22 xis_xn.D.t3 xis_xn.D.t2 20667.7
R23 xis_xn.D.n0 xis_xn.D.t2 642.101
R24 xib_xn.D.n0 xib_xn.D.t0 152.351
R25 xib_xn.D.t1 xib_xn.D.n0 122.249
R26 xib_xn.D.t3 xib_xn.D.n0 1630.04
R27 xib_xn.D.t3 xib_xn.D.t2 73458.9
R28 xib_xn.D.n0 xib_xn.D.t2 1628.18
R29 xi1_xn.D.n0 xi1_xn.D.t0 130.582
R30 xi1_xn.D.t4 xi1_xn.D.n0 82.5235
R31 xi1_xn.D.n0 xi1_xn.D.t1 75.0564
R32 xi1_xn.D.n0 xi1_xn.D.t2 166.454
R33 xi1_xn.D.n0 xi1_xn.D.t3 130.124
R34 xi1_xn.D.t2 xi1_xn.D.t3 2128.89
R35 xi0_xn.D.n0 xi0_xn.D.t2 148.065
R36 xi0_xn.D.n1 xi0_xn.D.t0 132.546
R37 xi0_xn.D.n0 xi0_xn.D.t3 117.07
R38 xi0_xn.D.t4 xi0_xn.D.n1 85.3806
R39 xi0_xn.D.n1 xi0_xn.D.t1 77.9136
R40 xi0_xn.D.n1 xi0_xn.D.n0 13.3955
R41 xi0_xn.D.t6 xi0_xn.D.n0 974.939
R42 xi0_xn.D.t6 xi0_xn.D.t5 28540.1
R43 xi0_xn.D.n0 xi0_xn.D.t5 620.418
R44 xbuf_xn.D.n0 xbuf_xn.D.t1 139.494
R45 xbuf_xn.D.t0 xbuf_xn.D.n0 109.391
R46 xbuf_xn.D.t3 xbuf_xn.D.n0 1014.19
R47 xbuf_xn.D.t3 xbuf_xn.D.t2 18832.8
R48 xbuf_xn.D.n0 xbuf_xn.D.t2 648.785
R49 txp.n0 txp.t0 83.1187
R50 txp txp.n0 58.2502
R51 txp.t2 txp.n0 89.9128
R52 txp.t2 txp.t1 5436.49
R53 txp.n0 txp.t1 102.993
R54 txn.n0 txn.t0 84.5473
R55 txn txn.n0 59.5192
R56 txn.t2 txn.n0 91.3443
R57 txn.t2 txn.t1 5602.37
R58 txn.n0 txn.t1 104.418
R59 rxp rxp.t0 726.794
R60 rxn rxn.t0 726.259
R61 dout.t0 dout 211.625
R62 dout.t0 dout.t1 585.687
R63 dout dout.t1 266.289
R64 din din.t0 628.384
R65 din din.t1 985.871
R66 din.t0 din.t1 22919.8
R67 boost.n0 boost.t2 902.299
R68 boost.n0 boost.t0 592.976
R69 boost.n0 boost.t1 932.803
R70 boost.t0 boost.t1 86960.9
R71 boost boost.n0 15.4553
R72 boost boost.t3 7807.84
R73 boost.n0 boost.t3 1022.22
R74 VGND.n98 VGND.n97 1112.72
R75 VGND.n97 VGND.n96 1112.72
R76 VGND.n96 VGND.n95 1112.72
R77 VGND.n95 VGND.n94 1112.72
R78 VGND.n104 VGND.n103 1108.2
R79 VGND.n100 VGND.n99 1087.39
R80 VGND.n101 VGND.n100 1087.39
R81 VGND.n102 VGND.n101 1087.39
R82 VGND.n103 VGND.n102 1087.39
R83 VGND.n8 VGND.n6 584.052
R84 VGND.n12 VGND.n9 585
R85 VGND.n20 VGND.n19 585
R86 VGND.n24 VGND.n21 585
R87 VGND.n30 VGND.n29 585
R88 VGND.n34 VGND.n31 585
R89 VGND.n40 VGND.n39 585
R90 VGND.n44 VGND.n41 585
R91 VGND.n50 VGND.n49 585
R92 VGND.n54 VGND.n51 585
R93 VGND.n60 VGND.n59 585
R94 VGND.n64 VGND.n61 585
R95 VGND.n70 VGND.n69 585
R96 VGND.n74 VGND.n71 585
R97 VGND.n115 VGND.n76 585
R98 VGND.n117 VGND.n72 585
R99 VGND.n119 VGND.n67 585
R100 VGND.n121 VGND.n62 585
R101 VGND.n123 VGND.n57 585
R102 VGND.n125 VGND.n52 585
R103 VGND.n127 VGND.n47 585
R104 VGND.n130 VGND.n42 585
R105 VGND.n132 VGND.n37 585
R106 VGND.n134 VGND.n32 585
R107 VGND.n136 VGND.n27 585
R108 VGND.n138 VGND.n22 585
R109 VGND.n140 VGND.n17 585
R110 VGND.n142 VGND.n10 585
R111 VGND.n144 VGND.n7 585
R112 VGND.n13 VGND.n6 585
R113 VGND.n14 VGND.n12 585
R114 VGND.n19 VGND.n16 585
R115 VGND.n25 VGND.n24 585
R116 VGND.n29 VGND.n26 585
R117 VGND.n35 VGND.n34 585
R118 VGND.n39 VGND.n36 585
R119 VGND.n45 VGND.n44 585
R120 VGND.n49 VGND.n46 585
R121 VGND.n55 VGND.n54 585
R122 VGND.n59 VGND.n56 585
R123 VGND.n65 VGND.n64 585
R124 VGND.n69 VGND.n66 585
R125 VGND.n75 VGND.n74 585
R126 VGND.n117 VGND.n73 585
R127 VGND.n119 VGND.n68 585
R128 VGND.n121 VGND.n63 585
R129 VGND.n123 VGND.n58 585
R130 VGND.n125 VGND.n53 585
R131 VGND.n127 VGND.n48 585
R132 VGND.n130 VGND.n43 585
R133 VGND.n132 VGND.n38 585
R134 VGND.n134 VGND.n33 585
R135 VGND.n136 VGND.n28 585
R136 VGND.n138 VGND.n23 585
R137 VGND.n140 VGND.n18 585
R138 VGND.n142 VGND.n11 585
R139 VGND.n13 VGND.n7 390.378
R140 VGND.n129 VGND.n0 74.5493
R141 VGND.n131 VGND.n0 74.5493
R142 VGND.n115 VGND.n74 73.1151
R143 VGND.n117 VGND.n74 73.8224
R144 VGND.n117 VGND.n69 73.8224
R145 VGND.n119 VGND.n69 73.8224
R146 VGND.n119 VGND.n64 73.8224
R147 VGND.n121 VGND.n64 73.8224
R148 VGND.n121 VGND.n59 73.8224
R149 VGND.n123 VGND.n59 73.8224
R150 VGND.n123 VGND.n54 73.8224
R151 VGND.n125 VGND.n54 73.8224
R152 VGND.n125 VGND.n49 73.8224
R153 VGND.n127 VGND.n49 73.8224
R154 VGND.n127 VGND.n44 73.8224
R155 VGND.n130 VGND.n44 73.8224
R156 VGND.n130 VGND.n39 73.8224
R157 VGND.n132 VGND.n39 73.8224
R158 VGND.n132 VGND.n34 73.8224
R159 VGND.n134 VGND.n34 73.8224
R160 VGND.n134 VGND.n29 73.8224
R161 VGND.n136 VGND.n29 73.8224
R162 VGND.n136 VGND.n24 73.8224
R163 VGND.n138 VGND.n24 73.8224
R164 VGND.n138 VGND.n19 73.8224
R165 VGND.n140 VGND.n19 73.8224
R166 VGND.n140 VGND.n12 73.8224
R167 VGND.n142 VGND.n12 73.8224
R168 VGND.n142 VGND.n6 73.8224
R169 VGND.n144 VGND.n6 72.3463
R170 VGND.n93 VGND.n92 1.7865
R171 VGND.n2 VGND.n3 1.7865
R172 VGND.n1 VGND.n2 1.7865
R173 VGND VGND.n3 1.0533
R174 VGND.n144 VGND.n5 295.082
R175 VGND.n143 VGND.n9 507.332
R176 VGND.n15 VGND.n7 528.249
R177 VGND.n137 VGND.n16 507.332
R178 VGND.n139 VGND.n21 507.332
R179 VGND.n133 VGND.n26 507.332
R180 VGND.n135 VGND.n31 517.321
R181 VGND.n129 VGND.n36 480.139
R182 VGND.n131 VGND.n126 45.6407
R183 VGND.n131 VGND.n41 680.484
R184 VGND.n126 VGND.n41 813.115
R185 VGND.n128 VGND.n46 507.332
R186 VGND.n122 VGND.n51 507.332
R187 VGND.n124 VGND.n56 507.332
R188 VGND.n118 VGND.n61 507.332
R189 VGND.n120 VGND.n66 507.332
R190 VGND.n114 VGND.n71 443.702
R191 VGND.n77 VGND.n11 443.592
R192 VGND.n78 VGND.n18 507.332
R193 VGND.n78 VGND.n23 507.332
R194 VGND.n79 VGND.n28 507.332
R195 VGND.n79 VGND.n33 507.332
R196 VGND.n80 VGND.n38 507.332
R197 VGND.n80 VGND.n43 507.332
R198 VGND.n81 VGND.n48 507.332
R199 VGND.n81 VGND.n53 507.332
R200 VGND.n82 VGND.n58 507.332
R201 VGND.n82 VGND.n63 507.332
R202 VGND.n83 VGND.n68 507.332
R203 VGND.n83 VGND.n73 489.091
R204 VGND.n115 VGND.n85 342.043
R205 VGND.n115 VGND.n86 293.308
R206 VGND.n85 VGND.n86 914.658
R207 VGND.n88 VGND.n113 2560.27
R208 VGND.n88 VGND.n94 2742.84
R209 VGND.n113 VGND.n94 3740.9
R210 VGND.n0 VGND.n93 4.58082
R211 VGND.n0 VGND.n89 191.185
R212 VGND.n93 VGND.n89 125.126
R213 VGND.n90 VGND.t1 3.58683
R214 VGND.n92 VGND.n90 3.61529
R215 VGND.n92 VGND.n91 150.885
R216 VGND.n90 VGND.n91 150.885
R217 VGND.n105 VGND.n10 431.589
R218 VGND.n106 VGND.n17 507.332
R219 VGND.n106 VGND.n22 507.332
R220 VGND.n107 VGND.n27 507.332
R221 VGND.n107 VGND.n32 507.332
R222 VGND.n108 VGND.n37 507.332
R223 VGND.n108 VGND.n42 507.332
R224 VGND.n109 VGND.n47 507.332
R225 VGND.n109 VGND.n52 507.332
R226 VGND.n110 VGND.n57 507.332
R227 VGND.n110 VGND.n62 507.332
R228 VGND.n111 VGND.n67 507.332
R229 VGND.n111 VGND.n72 507.332
R230 VGND.n112 VGND.n76 443.702
R231 VGND.n116 VGND.n75 443.692
R232 VGND.n118 VGND.n70 507.332
R233 VGND.n120 VGND.n65 507.332
R234 VGND.n122 VGND.n60 507.332
R235 VGND.n124 VGND.n55 507.332
R236 VGND.n126 VGND.n50 507.332
R237 VGND.n129 VGND.n128 45.6407
R238 VGND.n129 VGND.n45 680.484
R239 VGND.n128 VGND.n45 813.115
R240 VGND.n131 VGND.n40 480.139
R241 VGND.n133 VGND.n35 517.321
R242 VGND.n135 VGND.n30 507.332
R243 VGND.n137 VGND.n25 507.332
R244 VGND.n139 VGND.n20 507.332
R245 VGND.n141 VGND.n14 507.332
R246 VGND.n143 VGND.n8 368.195
R247 VGND.n4 VGND.n145 1461.42
R248 VGND.n4 VGND.n146 746.348
R249 VGND.n145 VGND.n146 728.788
R250 VGND.n11 VGND.n6 1760.11
R251 VGND.n77 VGND.n6 1870.09
R252 VGND.n145 VGND.n7 1113.56
R253 VGND.n145 VGND.n15 176.032
R254 VGND.n7 VGND.n141 1858.52
R255 VGND.n15 VGND.n141 81.3306
R256 VGND.n15 VGND.n13 1858.52
R257 VGND.n141 VGND.n13 620.966
R258 VGND.n11 VGND.n18 1246.43
R259 VGND.n11 VGND.n12 1915.88
R260 VGND.n18 VGND.n12 1915.88
R261 VGND.n18 VGND.n23 1318.72
R262 VGND.n18 VGND.n19 1958
R263 VGND.n23 VGND.n19 1958
R264 VGND.n78 VGND.n19 2907.18
R265 VGND.n23 VGND.n28 1246.43
R266 VGND.n23 VGND.n24 1915.88
R267 VGND.n28 VGND.n24 1915.88
R268 VGND.n28 VGND.n33 1318.72
R269 VGND.n28 VGND.n29 1958
R270 VGND.n33 VGND.n29 1958
R271 VGND.n79 VGND.n29 2907.18
R272 VGND.n33 VGND.n38 1246.43
R273 VGND.n33 VGND.n34 1915.88
R274 VGND.n38 VGND.n34 1915.88
R275 VGND.n38 VGND.n43 1318.72
R276 VGND.n38 VGND.n39 1958
R277 VGND.n43 VGND.n39 1958
R278 VGND.n80 VGND.n39 2907.18
R279 VGND.n43 VGND.n48 1246.43
R280 VGND.n43 VGND.n44 1915.88
R281 VGND.n48 VGND.n44 1915.88
R282 VGND.n48 VGND.n53 1318.72
R283 VGND.n48 VGND.n49 1958
R284 VGND.n53 VGND.n49 1958
R285 VGND.n81 VGND.n49 2907.18
R286 VGND.n53 VGND.n58 1246.43
R287 VGND.n53 VGND.n54 1915.88
R288 VGND.n58 VGND.n54 1915.88
R289 VGND.n58 VGND.n63 1318.72
R290 VGND.n58 VGND.n59 1958
R291 VGND.n63 VGND.n59 1958
R292 VGND.n82 VGND.n59 2907.18
R293 VGND.n63 VGND.n68 1246.43
R294 VGND.n63 VGND.n64 1915.88
R295 VGND.n68 VGND.n64 1915.88
R296 VGND.n68 VGND.n73 1318.72
R297 VGND.n68 VGND.n69 1958
R298 VGND.n73 VGND.n69 1958
R299 VGND.n83 VGND.n69 2907.18
R300 VGND.n73 VGND.n74 1713.93
R301 VGND.n85 VGND.t12 86.1708
R302 VGND.n10 VGND.n6 1756.4
R303 VGND.n105 VGND.n6 1733.22
R304 VGND.n10 VGND.n17 1246.43
R305 VGND.n10 VGND.n12 1915.88
R306 VGND.n17 VGND.n12 1915.88
R307 VGND.n17 VGND.n22 1318.72
R308 VGND.n17 VGND.n19 1958
R309 VGND.n22 VGND.n19 1958
R310 VGND.n106 VGND.n19 2907.18
R311 VGND.n22 VGND.n27 1246.43
R312 VGND.n22 VGND.n24 1915.88
R313 VGND.n27 VGND.n24 1915.88
R314 VGND.n27 VGND.n32 1318.72
R315 VGND.n27 VGND.n29 1958
R316 VGND.n32 VGND.n29 1958
R317 VGND.n107 VGND.n29 2907.18
R318 VGND.n32 VGND.n37 1246.43
R319 VGND.n32 VGND.n34 1915.88
R320 VGND.n37 VGND.n34 1915.88
R321 VGND.n37 VGND.n42 1318.72
R322 VGND.n37 VGND.n39 1958
R323 VGND.n42 VGND.n39 1958
R324 VGND.n108 VGND.n39 2907.18
R325 VGND.n42 VGND.n47 1246.43
R326 VGND.n42 VGND.n44 1915.88
R327 VGND.n47 VGND.n44 1915.88
R328 VGND.n47 VGND.n52 1318.72
R329 VGND.n47 VGND.n49 1958
R330 VGND.n52 VGND.n49 1958
R331 VGND.n109 VGND.n49 2907.18
R332 VGND.n52 VGND.n57 1246.43
R333 VGND.n52 VGND.n54 1915.88
R334 VGND.n57 VGND.n54 1915.88
R335 VGND.n57 VGND.n62 1318.72
R336 VGND.n57 VGND.n59 1958
R337 VGND.n62 VGND.n59 1958
R338 VGND.n110 VGND.n59 2907.18
R339 VGND.n62 VGND.n67 1246.43
R340 VGND.n62 VGND.n64 1915.88
R341 VGND.n67 VGND.n64 1915.88
R342 VGND.n67 VGND.n72 1318.72
R343 VGND.n67 VGND.n69 1958
R344 VGND.n72 VGND.n69 1958
R345 VGND.n111 VGND.n69 2907.18
R346 VGND.n72 VGND.n76 1246.43
R347 VGND.n72 VGND.n74 1915.88
R348 VGND.n76 VGND.n74 1915.88
R349 VGND.t11 VGND.n86 93.7056
R350 VGND.n75 VGND.n115 1760.43
R351 VGND.n116 VGND.n115 1871.28
R352 VGND.n66 VGND.n75 1246.43
R353 VGND.n66 VGND.n117 1915.88
R354 VGND.n75 VGND.n117 1915.88
R355 VGND.n70 VGND.n71 1246.43
R356 VGND.n70 VGND.n117 1915.88
R357 VGND.n71 VGND.n117 1915.88
R358 VGND.n61 VGND.n70 1318.72
R359 VGND.n61 VGND.n119 1958
R360 VGND.n70 VGND.n119 1958
R361 VGND.n118 VGND.n119 2907.18
R362 VGND.n65 VGND.n66 1318.72
R363 VGND.n65 VGND.n119 1958
R364 VGND.n66 VGND.n119 1958
R365 VGND.n120 VGND.n119 2907.18
R366 VGND.n56 VGND.n65 1246.43
R367 VGND.n56 VGND.n121 1915.88
R368 VGND.n65 VGND.n121 1915.88
R369 VGND.n60 VGND.n61 1246.43
R370 VGND.n60 VGND.n121 1915.88
R371 VGND.n61 VGND.n121 1915.88
R372 VGND.n51 VGND.n60 1318.72
R373 VGND.n51 VGND.n123 1958
R374 VGND.n60 VGND.n123 1958
R375 VGND.n122 VGND.n123 2907.18
R376 VGND.n55 VGND.n56 1318.72
R377 VGND.n55 VGND.n123 1958
R378 VGND.n56 VGND.n123 1958
R379 VGND.n124 VGND.n123 2907.18
R380 VGND.n46 VGND.n55 1246.43
R381 VGND.n46 VGND.n125 1915.88
R382 VGND.n55 VGND.n125 1915.88
R383 VGND.n50 VGND.n51 1246.43
R384 VGND.n50 VGND.n125 1915.88
R385 VGND.n51 VGND.n125 1915.88
R386 VGND.n41 VGND.n50 1318.72
R387 VGND.n41 VGND.n127 1958
R388 VGND.n50 VGND.n127 1958
R389 VGND.n126 VGND.n127 2907.18
R390 VGND.n45 VGND.n46 1318.72
R391 VGND.n45 VGND.n127 1958
R392 VGND.n46 VGND.n127 1958
R393 VGND.n128 VGND.n127 2907.18
R394 VGND.n36 VGND.n45 1318.72
R395 VGND.n36 VGND.n130 1958
R396 VGND.n45 VGND.n130 1958
R397 VGND.n129 VGND.n130 2907.18
R398 VGND.n40 VGND.n41 1318.72
R399 VGND.n40 VGND.n130 1958
R400 VGND.n41 VGND.n130 1958
R401 VGND.n131 VGND.n130 2907.18
R402 VGND.n31 VGND.n40 1256.26
R403 VGND.n31 VGND.n132 1918.39
R404 VGND.n40 VGND.n132 1921.78
R405 VGND.n35 VGND.n36 1256.26
R406 VGND.n35 VGND.n132 1918.39
R407 VGND.n36 VGND.n132 1921.78
R408 VGND.n26 VGND.n35 1318.72
R409 VGND.n26 VGND.n134 1958
R410 VGND.n35 VGND.n134 1958
R411 VGND.n133 VGND.n134 2907.18
R412 VGND.n30 VGND.n31 1318.72
R413 VGND.n30 VGND.n134 1958
R414 VGND.n31 VGND.n134 1958
R415 VGND.n135 VGND.n134 2907.18
R416 VGND.n21 VGND.n30 1246.43
R417 VGND.n21 VGND.n136 1915.88
R418 VGND.n30 VGND.n136 1915.88
R419 VGND.n25 VGND.n26 1246.43
R420 VGND.n25 VGND.n136 1915.88
R421 VGND.n26 VGND.n136 1915.88
R422 VGND.n16 VGND.n25 1318.72
R423 VGND.n16 VGND.n138 1958
R424 VGND.n25 VGND.n138 1958
R425 VGND.n137 VGND.n138 2907.18
R426 VGND.n20 VGND.n21 1318.72
R427 VGND.n20 VGND.n138 1958
R428 VGND.n21 VGND.n138 1958
R429 VGND.n139 VGND.n138 2907.18
R430 VGND.n9 VGND.n20 1246.43
R431 VGND.n9 VGND.n140 1915.88
R432 VGND.n20 VGND.n140 1915.88
R433 VGND.n14 VGND.n16 1246.43
R434 VGND.n14 VGND.n140 1915.88
R435 VGND.n16 VGND.n140 1915.88
R436 VGND.n13 VGND.n14 1318.72
R437 VGND.n13 VGND.n142 1958
R438 VGND.n14 VGND.n142 1958
R439 VGND.n141 VGND.n142 2907.18
R440 VGND.n8 VGND.n9 1318.72
R441 VGND.n8 VGND.n142 1958
R442 VGND.n9 VGND.n142 1958
R443 VGND.n143 VGND.n142 2907.18
R444 VGND.n12 VGND.n78 6276.49
R445 VGND.n12 VGND.n77 6276.49
R446 VGND.n18 VGND.n77 1602.64
R447 VGND.n78 VGND.n11 1602.64
R448 VGND.n78 VGND.n77 112.957
R449 VGND.n24 VGND.n79 6276.49
R450 VGND.n24 VGND.n78 6276.49
R451 VGND.n28 VGND.n78 1602.64
R452 VGND.n79 VGND.n23 1602.64
R453 VGND.n79 VGND.n78 112.957
R454 VGND.n34 VGND.n80 6276.49
R455 VGND.n34 VGND.n79 6276.49
R456 VGND.n38 VGND.n79 1602.64
R457 VGND.n80 VGND.n33 1602.64
R458 VGND.n80 VGND.n79 112.957
R459 VGND.n44 VGND.n81 6276.49
R460 VGND.n44 VGND.n80 6276.49
R461 VGND.n48 VGND.n80 1602.64
R462 VGND.n81 VGND.n43 1602.64
R463 VGND.n81 VGND.n80 112.957
R464 VGND.n54 VGND.n82 6276.49
R465 VGND.n54 VGND.n81 6276.49
R466 VGND.n58 VGND.n81 1602.64
R467 VGND.n82 VGND.n53 1602.64
R468 VGND.n82 VGND.n81 112.957
R469 VGND.n64 VGND.n83 6276.49
R470 VGND.n64 VGND.n82 6276.49
R471 VGND.n68 VGND.n82 1602.64
R472 VGND.n83 VGND.n63 1602.64
R473 VGND.n83 VGND.n82 112.957
R474 VGND.n74 VGND.n84 3011.27
R475 VGND.n74 VGND.n83 4827.29
R476 VGND.n84 VGND.n73 1124.2
R477 VGND.n84 VGND.n83 110.382
R478 VGND.n116 VGND.n4 194.804
R479 VGND.n4 VGND.t12 86.0949
R480 VGND.n84 VGND.n85 168.221
R481 VGND.n114 VGND.n86 198.983
R482 VGND.n87 VGND.n86 239.008
R483 VGND.t11 VGND.n87 432.226
R484 VGND.n12 VGND.n106 6276.49
R485 VGND.n12 VGND.n105 6276.49
R486 VGND.n17 VGND.n105 1602.64
R487 VGND.n106 VGND.n10 1602.64
R488 VGND.n106 VGND.n105 112.957
R489 VGND.n24 VGND.n107 6276.49
R490 VGND.n24 VGND.n106 6276.49
R491 VGND.n27 VGND.n106 1602.64
R492 VGND.n107 VGND.n22 1602.64
R493 VGND.n107 VGND.n106 112.957
R494 VGND.n34 VGND.n108 6276.49
R495 VGND.n34 VGND.n107 6276.49
R496 VGND.n37 VGND.n107 1602.64
R497 VGND.n108 VGND.n32 1602.64
R498 VGND.n108 VGND.n107 112.957
R499 VGND.n44 VGND.n109 6276.49
R500 VGND.n44 VGND.n108 6276.49
R501 VGND.n47 VGND.n108 1602.64
R502 VGND.n109 VGND.n42 1602.64
R503 VGND.n109 VGND.n108 112.957
R504 VGND.n54 VGND.n110 6276.49
R505 VGND.n54 VGND.n109 6276.49
R506 VGND.n57 VGND.n109 1602.64
R507 VGND.n110 VGND.n52 1602.64
R508 VGND.n110 VGND.n109 112.957
R509 VGND.n64 VGND.n111 6276.49
R510 VGND.n64 VGND.n110 6276.49
R511 VGND.n67 VGND.n110 1602.64
R512 VGND.n111 VGND.n62 1602.64
R513 VGND.n111 VGND.n110 112.957
R514 VGND.n74 VGND.n112 6276.49
R515 VGND.n74 VGND.n111 6276.49
R516 VGND.n76 VGND.n111 1602.64
R517 VGND.n112 VGND.n72 1602.64
R518 VGND.n112 VGND.n111 112.957
R519 VGND.n112 VGND.n113 179.575
R520 VGND.n76 VGND.n113 1113.28
R521 VGND.n113 VGND.t11 91.9398
R522 VGND.n117 VGND.n116 6276.49
R523 VGND.n117 VGND.n120 6276.49
R524 VGND.n75 VGND.n120 1602.64
R525 VGND.n116 VGND.n66 1602.64
R526 VGND.n116 VGND.n120 112.957
R527 VGND.n117 VGND.n118 6276.49
R528 VGND.n117 VGND.n114 6276.49
R529 VGND.n70 VGND.n114 1602.64
R530 VGND.n118 VGND.n71 1602.64
R531 VGND.n118 VGND.n114 112.957
R532 VGND.n121 VGND.n120 6276.49
R533 VGND.n121 VGND.n124 6276.49
R534 VGND.n65 VGND.n124 1602.64
R535 VGND.n120 VGND.n56 1602.64
R536 VGND.n120 VGND.n124 112.957
R537 VGND.n121 VGND.n122 6276.49
R538 VGND.n121 VGND.n118 6276.49
R539 VGND.n60 VGND.n118 1602.64
R540 VGND.n122 VGND.n61 1602.64
R541 VGND.n122 VGND.n118 112.957
R542 VGND.n125 VGND.n124 6276.49
R543 VGND.n125 VGND.n128 6276.49
R544 VGND.n55 VGND.n128 1602.64
R545 VGND.n124 VGND.n46 1602.64
R546 VGND.n124 VGND.n128 112.957
R547 VGND.n125 VGND.n126 6276.49
R548 VGND.n125 VGND.n122 6276.49
R549 VGND.n50 VGND.n122 1602.64
R550 VGND.n126 VGND.n51 1602.64
R551 VGND.n126 VGND.n122 112.957
R552 VGND.n132 VGND.n131 5830.75
R553 VGND.n132 VGND.n135 6684.16
R554 VGND.n40 VGND.n135 1869.5
R555 VGND.n131 VGND.n31 1488.83
R556 VGND.n131 VGND.n135 104.936
R557 VGND.n132 VGND.n133 6684.16
R558 VGND.n132 VGND.n129 5830.75
R559 VGND.n35 VGND.n129 1488.83
R560 VGND.n133 VGND.n36 1869.5
R561 VGND.n133 VGND.n129 104.936
R562 VGND.n136 VGND.n135 6276.49
R563 VGND.n136 VGND.n139 6276.49
R564 VGND.n30 VGND.n139 1602.64
R565 VGND.n135 VGND.n21 1602.64
R566 VGND.n135 VGND.n139 112.957
R567 VGND.n136 VGND.n137 6276.49
R568 VGND.n136 VGND.n133 6276.49
R569 VGND.n25 VGND.n133 1602.64
R570 VGND.n137 VGND.n26 1602.64
R571 VGND.n137 VGND.n133 112.957
R572 VGND.n140 VGND.n139 6276.49
R573 VGND.n140 VGND.n143 6276.49
R574 VGND.n20 VGND.n143 1602.64
R575 VGND.n139 VGND.n9 1602.64
R576 VGND.n139 VGND.n143 112.957
R577 VGND.n140 VGND.n141 6276.49
R578 VGND.n140 VGND.n137 6276.49
R579 VGND.n14 VGND.n137 1602.64
R580 VGND.n141 VGND.n16 1602.64
R581 VGND.n141 VGND.n137 112.957
R582 VGND.n77 VGND.n5 219.605
R583 VGND.n148 VGND.n1 157.347
R584 VGND.n115 VGND.n4 4481.57
R585 VGND.n75 VGND.n4 3018.35
R586 VGND.n113 VGND.n87 309.533
R587 VGND.n143 VGND.n144 662.129
R588 VGND.n8 VGND.n144 1256.26
R589 VGND.t19 VGND.n149 23.1772
R590 VGND.n148 VGND.t0 237.603
R591 VGND.n147 VGND.t16 242.046
R592 VGND.t13 VGND.n146 23.1756
R593 VGND.n96 VGND.n91 1223
R594 VGND.n87 VGND.n112 4001.42
R595 VGND.n114 VGND.n87 3595.53
R596 VGND.n147 VGND.t15 23.8111
R597 VGND.n148 VGND.t17 23.0376
R598 VGND.n103 VGND.t9 882.965
R599 VGND.t1 VGND.t4 338.928
R600 VGND.n105 VGND.n104 2300.89
R601 VGND.n98 VGND.t3 1269.51
R602 VGND.n97 VGND.t8 1272.17
R603 VGND.n91 VGND.t7 195.452
R604 VGND.n96 VGND.t7 1728.29
R605 VGND.n95 VGND.t5 1272.17
R606 VGND.t2 VGND.n3 166.868
R607 VGND.n149 VGND.n3 2191.37
R608 VGND.n3 VGND.t19 212.827
R609 VGND.t18 VGND.n2 181.328
R610 VGND.t0 VGND.n2 195.982
R611 VGND.t17 VGND.n1 2584.76
R612 VGND.n147 VGND.n1 286.868
R613 VGND.t16 VGND.n1 192.266
R614 VGND.t6 VGND.t1 261.539
R615 VGND.n99 VGND.n98 10597.3
R616 VGND.n99 VGND.t3 1269.51
R617 VGND.n100 VGND.n97 15908.7
R618 VGND.n100 VGND.t8 1272.17
R619 VGND.n100 VGND.n90 1838.57
R620 VGND.t8 VGND.n90 293.829
R621 VGND.n97 VGND.n90 1838.57
R622 VGND.n91 VGND.n101 1223
R623 VGND.n101 VGND.n96 33664.3
R624 VGND.n101 VGND.t7 1728.29
R625 VGND.n102 VGND.n95 15908.7
R626 VGND.n102 VGND.t5 1272.17
R627 VGND.n102 VGND.n92 1838.57
R628 VGND.t5 VGND.n92 293.829
R629 VGND.n95 VGND.n92 1838.57
R630 VGND.n104 VGND.n144 5580.47
R631 VGND.n104 VGND.n8 35697.9
R632 VGND.n104 VGND.n143 6091.82
R633 VGND.n105 VGND.n144 660.697
R634 VGND.n105 VGND.n8 7249.8
R635 VGND.n105 VGND.n143 1235.62
R636 VGND.t18 VGND.n149 266.07
R637 VGND.n2 VGND.n149 1813.34
R638 VGND.n143 VGND.n6 61420.4
R639 VGND.n143 VGND.n10 41366.9
R640 VGND.n104 VGND.n6 111819
R641 VGND.n104 VGND.n10 75310.7
R642 VGND.n10 VGND.n144 4583.82
R643 VGND.t13 VGND.n0 375.418
R644 VGND.n146 VGND.n0 3865.37
R645 VGND.n104 VGND.n89 1742.91
R646 VGND.n88 VGND.n89 462.132
R647 VGND.t6 VGND.t4 8976.46
R648 VGND.t6 VGND.n98 3609.4
R649 VGND.t4 VGND.n98 15778.8
R650 VGND.t1 VGND.n98 1954.4
R651 VGND.t6 VGND.n99 3558.86
R652 VGND.t4 VGND.n99 15271.7
R653 VGND.t1 VGND.n99 1937.92
R654 VGND.n10 VGND.n5 143088
R655 VGND.n104 VGND.n5 21048.2
R656 VGND.n105 VGND.n5 4282.32
R657 VGND.n8 VGND.n5 16872.3
R658 VGND.n143 VGND.n5 2927.31
R659 VGND.n0 VGND.t14 583.001
R660 VGND.n146 VGND.t14 3328.4
R661 VGND.t13 VGND.t14 320.901
R662 VGND.n147 VGND.t17 54986.1
R663 VGND.n148 VGND.t16 3334.67
R664 VGND.t16 VGND.t17 311.882
R665 VGND.n149 VGND.t0 38500.6
R666 VGND.n148 VGND.t18 35273.7
R667 VGND.t0 VGND.t18 297.837
R668 VGND.t19 VGND.t2 321.248
R669 VGND.n149 VGND.t2 3332.17
R670 VGND.t9 VGND.n93 335.877
R671 VGND.n103 VGND.n93 1017.33
R672 VGND.n89 VGND.t10 206.577
R673 VGND.n88 VGND.t10 913.971
R674 VGND.t10 VGND.n104 3446.99
R675 VGND.n88 VGND.n104 15328.5
R676 VGND.n99 VGND.n90 3691.9
R677 VGND.t3 VGND.t1 590.013
R678 VGND.t3 VGND.n90 590.013
R679 VGND.n98 VGND.n90 3691.89
R680 VGND.n94 VGND.t9 882.965
R681 VGND.n93 VGND.n94 1017.33
R682 VGND.n94 VGND.n103 4113.98
R683 VGND.n145 VGND.n5 137.624
R684 VGND.n77 VGND.n145 9958.05
R685 VGND.n77 VGND.n15 171587
R686 VGND.n15 VGND.n5 7283.57
R687 VGND.n86 VGND.n71 3028.96
R688 VGND.n71 VGND.n115 1760.37
R689 VGND.n114 VGND.n115 1871.4
R690 VGND.n85 VGND.n83 12155.9
R691 VGND.n85 VGND.n74 14531.8
R692 VGND.n85 VGND.n73 9454.11
R693 VGND.n83 VGND.n115 6383.79
R694 VGND.n73 VGND.n115 4964.91
R695 VGND.n84 VGND.n115 1767.27
R696 VGND.n84 VGND.n4 9683.98
R697 VGND.n84 VGND.t12 13426.5
R698 VGND.n85 VGND.n4 739.928
R699 VGND.t13 VGND.n147 55721.2
R700 VGND.t13 VGND.t15 38199.9
R701 VGND.n147 VGND.t14 4487.78
R702 VGND.t14 VGND.t15 316.757
R703 VGND.n146 VGND.n1 5274.28
R704 VGND.t13 VGND.n1 512.223
R705 VGND.t14 VGND.n1 262.635
R706 VGND.t15 VGND.n0 2015.81
R707 VGND.t15 VGND.n1 811.691
R708 VGND.n147 VGND.n0 739.72
R709 VGND.n0 VGND.n1 6.34133
R710 VGND.n85 VGND.n116 11396.8
R711 VGND.n84 VGND.n116 147568
R712 VGND.n116 VGND.t12 14659.3
R713 VGND.n5 VGND.n6 10590.1
R714 VGND.n5 VGND.n11 7132.46
R715 VGND.n11 VGND.n144 5203.1
R716 VGND.n77 VGND.n144 1566.25
R717 VDPWR.n1 VDPWR.t0 110.837
R718 VDPWR.n3 VDPWR.t4 101.216
R719 VDPWR.n4 VDPWR.t10 99.9268
R720 VDPWR.n5 VDPWR.t2 99.9268
R721 VDPWR.n3 VDPWR.t8 99.9268
R722 VDPWR.n1 VDPWR.t14 58.327
R723 VDPWR.n1 VDPWR.t16 58.327
R724 VDPWR.n2 VDPWR.n3 18.218
R725 VDPWR VDPWR.n0 9.03449
R726 VDPWR.n0 VDPWR.n8 3.62244
R727 VDPWR.n3 VDPWR.n5 2.28235
R728 VDPWR.n1 VDPWR.n4 9.10902
R729 VDPWR.n1 VDPWR.t6 509.62
R730 VDPWR.n4 VDPWR.t6 126.52
R731 VDPWR.n4 VDPWR.n5 3.60442
R732 VDPWR.n4 VDPWR.t12 201.639
R733 VDPWR.n5 VDPWR.t12 201.639
R734 VDPWR.n6 VDPWR.n2 4.15878
R735 VDPWR.n7 VDPWR.n6 3.59033
R736 VDPWR.n8 VDPWR.n7 3.59163
R737 VDPWR.t1 VDPWR.n2 416.406
R738 VDPWR.t1 VDPWR.n6 316.627
R739 VDPWR.t9 VDPWR.n6 359.483
R740 VDPWR.t9 VDPWR.n7 359.483
R741 VDPWR.t17 VDPWR.n7 335.354
R742 VDPWR.t17 VDPWR.n8 335.354
R743 VDPWR.t15 VDPWR.n0 173.65
R744 VDPWR.t13 VDPWR.n0 173.65
R745 VDPWR.n2 VDPWR.t3 180.071
R746 VDPWR.n2 VDPWR.t7 178.849
R747 VDPWR.n6 VDPWR.t11 178.849
R748 VDPWR.n7 VDPWR.t5 178.849
R749 VDPWR.n8 VDPWR.t18 166.785
C0 xtp_xn.S.t1 xtn_xn.S.t1 27.4079f
C1 xtp_xn.S.t1 xn1.S.t0 0.28948f
C2 xtp_xn.S.t1 xn1.D.n0 0.38483f
C3 xtp_xn.S.t1 xis_xn.G.n0 0.37967f
C4 xtp_xn.S.t1 xis_xn.D.n0 0.37967f
C5 xtp_xn.S.t1 xib_xn.D.n0 0.55532f
C6 xtp_xn.S.t1 xi1_xn.D.n0 11.131f
C7 xtp_xn.S.t1 xi0_xn.D.n0 0.79348f
C8 xtp_xn.S.t1 xbuf_xn.D.n0 0.37967f
C9 xtp_xn.S.t1 xrbp.R2 0.54292f
C10 xtp_xn.S.t1 VDPWR 1.52749f
C11 xtp_xn.S.t1 rxn 0.33722f
C12 xtp_xn.S.t1 din 0.40334f
C13 xtp_xn.S.t1 boost 27.3711f
C14 xtp_xn.S.t1 dout 0.32234f
C15 xtp_xn.S.t1 rxp 0.33715f
C16 xtp_xn.S.t1 txp 1.07008f
C17 xtp_xn.S.t1 txn 0.28948f
C18 xtn_xn.S.t1 xn1.S.t0 0.38442f
C19 xtn_xn.S.t1 xn1.D.n0 0.77798f
C20 xtn_xn.S.t1 xis_xn.G.n0 0.36863f
C21 xtn_xn.S.t1 xis_xn.D.n0 0.36863f
C22 xtn_xn.S.t1 xib_xn.D.n0 0.54322f
C23 xtn_xn.S.t1 xi1_xn.D.n0 0.2739f
C24 xtn_xn.S.t1 xi0_xn.D.n0 11.7655f
C25 xtn_xn.S.t1 xbuf_xn.D.n0 0.36863f
C26 xtn_xn.S.t1 xrbp.R2 0.29745f
C27 xtn_xn.S.t1 VDPWR 1.53514f
C28 xtn_xn.S.t1 rxn 0.32385f
C29 xtn_xn.S.t1 din 0.39223f
C30 xtn_xn.S.t1 boost 0.58533f
C31 xtn_xn.S.t1 dout 0.2739f
C32 xtn_xn.S.t1 rxp 0.32375f
C33 xtn_xn.S.t1 txp 0.42352f
C34 xtn_xn.S.t1 txn 1.1131f
C35 xn1.S.t0 xn1.D.n0 3.37889f
C36 xn1.S.t0 xis_xn.G.n0 3.45905f
C37 xn1.S.t0 xis_xn.D.n0 0.26054f
C38 xn1.S.t0 xib_xn.D.n0 0.26002f
C39 xn1.S.t0 xi1_xn.D.n0 0.53297f
C40 xn1.S.t0 xi0_xn.D.n0 0.53326f
C41 xn1.S.t0 xbuf_xn.D.n0 0.26097f
C42 xn1.S.t0 xrbp.R2 0.36486f
C43 xn1.S.t0 VDPWR 0.88694f
C44 xn1.S.t0 rxn 1.61637f
C45 xn1.S.t0 din 0.15522f
C46 xn1.S.t0 boost 0.15488f
C47 xn1.S.t0 dout 0.26001f
C48 xn1.S.t0 rxp 28.3915f
C49 xn1.S.t0 txp 0.30518f
C50 xn1.S.t0 txn 27.2477f
C51 xn1.D.n0 xis_xn.G.n0 28.0541f
C52 xn1.D.n0 xis_xn.D.n0 0.3523f
C53 xn1.D.n0 xib_xn.D.n0 0.36066f
C54 xn1.D.n0 xi1_xn.D.n0 27.2686f
C55 xn1.D.n0 xi0_xn.D.n0 0.54447f
C56 xn1.D.n0 xbuf_xn.D.n0 0.35105f
C57 xn1.D.n0 xrbp.R2 0.46052f
C58 xn1.D.n0 VDPWR 9.85599f
C59 xn1.D.n0 rxn 1.76777f
C60 xn1.D.n0 din 0.28515f
C61 xn1.D.n0 boost 0.25023f
C62 xn1.D.n0 dout 0.35721f
C63 xn1.D.n0 rxp 0.30788f
C64 xn1.D.n0 txp 0.25531f
C65 xn1.D.n0 txn 0.25531f
C66 xis_xn.G.n0 xis_xn.D.n0 27.2982f
C67 xis_xn.G.n0 xib_xn.D.n0 0.35029f
C68 xis_xn.G.n0 xi1_xn.D.n0 0.56901f
C69 xis_xn.G.n0 xi0_xn.D.n0 0.61354f
C70 xis_xn.G.n0 xbuf_xn.D.n0 0.35245f
C71 xis_xn.G.n0 xrbp.R2 0.45505f
C72 xis_xn.G.n0 VDPWR 7.45097f
C73 xis_xn.G.n0 rxn 0.30851f
C74 xis_xn.G.n0 din 0.30942f
C75 xis_xn.G.n0 boost 0.2451f
C76 xis_xn.G.n0 dout 0.35104f
C77 xis_xn.G.n0 rxp 1.76782f
C78 xis_xn.G.n0 txp 0.25543f
C79 xis_xn.G.n0 txn 0.25543f
C80 xis_xn.D.n0 xib_xn.D.n0 0.42238f
C81 xis_xn.D.n0 xi1_xn.D.n0 0.48773f
C82 xis_xn.D.n0 xi0_xn.D.n0 0.66682f
C83 xis_xn.D.n0 xbuf_xn.D.n0 27.36f
C84 xis_xn.D.n0 xrbp.R2 0.45505f
C85 xis_xn.D.n0 VDPWR 8.64585f
C86 xis_xn.D.n0 rxn 0.30943f
C87 xis_xn.D.n0 din 0.44479f
C88 xis_xn.D.n0 boost 0.2451f
C89 xis_xn.D.n0 dout 0.35072f
C90 xis_xn.D.n0 rxp 0.30841f
C91 xis_xn.D.n0 txp 0.26001f
C92 xis_xn.D.n0 txn 0.26035f
C93 xib_xn.D.n0 xi1_xn.D.n0 0.5141f
C94 xib_xn.D.n0 xi0_xn.D.n0 0.52529f
C95 xib_xn.D.n0 xbuf_xn.D.n0 0.3502f
C96 xib_xn.D.n0 xrbp.R2 27.0397f
C97 xib_xn.D.n0 VDPWR 9.18518f
C98 xib_xn.D.n0 rxn 0.30778f
C99 xib_xn.D.n0 din 0.36834f
C100 xib_xn.D.n0 boost 27.1939f
C101 xib_xn.D.n0 dout 0.26061f
C102 xib_xn.D.n0 rxp 0.30769f
C103 xib_xn.D.n0 txp 0.26001f
C104 xib_xn.D.n0 txn 0.26001f
C105 xi1_xn.D.n0 xi0_xn.D.n0 0.91881f
C106 xi1_xn.D.n0 xbuf_xn.D.n0 0.5012f
C107 xi1_xn.D.n0 xrbp.R2 0.36545f
C108 xi1_xn.D.n0 VDPWR 6.45484f
C109 xi1_xn.D.n0 rxn 0.46849f
C110 xi1_xn.D.n0 din 0.17572f
C111 xi1_xn.D.n0 boost 0.25627f
C112 xi1_xn.D.n0 dout 27.1419f
C113 xi1_xn.D.n0 rxp 0.48873f
C114 xi1_xn.D.n0 txp 1.19452f
C115 xi1_xn.D.n0 txn 0.47317f
C116 xi0_xn.D.n0 xbuf_xn.D.n0 0.50983f
C117 xi0_xn.D.n0 xrbp.R2 0.49865f
C118 xi0_xn.D.n0 VDPWR 8.42858f
C119 xi0_xn.D.n0 rxn 0.47033f
C120 xi0_xn.D.n0 din 27.4284f
C121 xi0_xn.D.n0 boost 0.3616f
C122 xi0_xn.D.n0 dout 27.2405f
C123 xi0_xn.D.n0 rxp 0.48664f
C124 xi0_xn.D.n0 txp 0.6611f
C125 xi0_xn.D.n0 txn 1.3955f
C126 xbuf_xn.D.n0 xrbp.R2 0.45505f
C127 xbuf_xn.D.n0 VDPWR 8.72945f
C128 xbuf_xn.D.n0 rxn 27.0843f
C129 xbuf_xn.D.n0 din 0.24617f
C130 xbuf_xn.D.n0 boost 0.2512f
C131 xbuf_xn.D.n0 dout 0.58153f
C132 xbuf_xn.D.n0 rxp 0.30937f
C133 xbuf_xn.D.n0 txp 0.26035f
C134 xbuf_xn.D.n0 txn 0.26054f
C135 xrbp.R2 VDPWR 2.03877f
C136 xrbp.R2 rxn 0.41261f
C137 xrbp.R2 din 27.2603f
C138 xrbp.R2 boost 0.15749f
C139 xrbp.R2 dout 0.36564f
C140 xrbp.R2 rxp 0.41254f
C141 xrbp.R2 txp 1.65707f
C142 xrbp.R2 txn 2.00092f
C143 VDPWR rxn 1.10032f
C144 VDPWR din 3.14153f
C145 VDPWR boost 3.64276f
C146 VDPWR dout 4.93183f
C147 VDPWR rxp 0.73655f
C148 VDPWR txp 27.6169f
C149 VDPWR txn 0.84546f
C150 rxn din 0.20338f
C151 rxn boost 0.20262f
C152 rxn dout 0.30775f
C153 rxn rxp 26.9833f
C154 rxn txp 0.15531f
C155 rxn txn 0.15565f
C156 din boost 0.25592f
C157 din dout 0.22823f
C158 din rxp 0.20305f
C159 din txp 0.15488f
C160 din txn 0.15506f
C161 boost dout 0.15522f
C162 boost rxp 0.20256f
C163 boost txp 0.15488f
C164 boost txn 0.15488f
C165 dout rxp 0.30769f
C166 dout txp 0.26001f
C167 dout txn 0.26001f
C168 rxp txp 0.15565f
C169 rxp txn 0.15665f
C170 txp txn 27.2925f
C171 txn VGND 7.2623f
C172 txp VGND 7.0732f
C173 rxp VGND 14.67596f
C174 dout VGND 14.02064f
C175 boost VGND 2.6247f
C176 din VGND 16.87652f
C177 rxn VGND 14.24201f
C178 VDPWR VGND 2.688f
C179 xrbp.R2 VGND 26.9984f
C180 VDPWR.n0 VGND 13.1127f
C181 VDPWR.n1 VGND 10.721f
C182 VDPWR.n2 VGND 10.8876f
C183 VDPWR.n3 VGND 7.66349f
C184 VDPWR.t3 VGND 2.73261f
C185 VDPWR.t0 VGND 0.69124f
C186 VDPWR.t14 VGND 1.36556f
C187 VDPWR.t16 VGND 1.36556f
C188 VDPWR.t6 VGND 0.48661f
C189 VDPWR.t10 VGND 0.44208f
C190 VDPWR.n4 VGND 5.28457f
C191 VDPWR.t12 VGND 0.45863f
C192 VDPWR.t2 VGND 0.44208f
C193 VDPWR.n5 VGND 2.79331f
C194 VDPWR.t8 VGND 0.44208f
C195 VDPWR.t4 VGND 0.47298f
C196 VDPWR.t7 VGND 2.70937f
C197 VDPWR.t1 VGND 2.72542f
C198 VDPWR.t11 VGND 2.70937f
C199 VDPWR.n6 VGND 5.86894f
C200 VDPWR.t9 VGND 2.7235f
C201 VDPWR.t5 VGND 2.70937f
C202 VDPWR.n7 VGND 5.71721f
C203 VDPWR.t17 VGND 4.51203f
C204 VDPWR.t18 VGND 4.49644f
C205 VDPWR.n8 VGND 4.65134f
C206 VDPWR.t15 VGND 5.76393f
C207 VDPWR.t13 VGND 5.76393f
C208 boost.t0 VGND 0.26985f
C209 boost.t1 VGND 0.19869f
C210 boost.t2 VGND 0.08744f
C211 boost.n0 VGND 20.6569f
C212 boost.t3 VGND 0.0927f
C213 din.t0 VGND 0.66267f
C214 din.t1 VGND 0.44452f
C215 dout.t0 VGND 3.48713f
C216 dout.t1 VGND 2.67092f
C217 rxn.t0 VGND 1.44659f
C218 rxp.t0 VGND 1.47414f
C219 txn.t2 VGND 0.21846f
C220 txn.t1 VGND 0.22385f
C221 txn.t0 VGND 0.1255f
C222 txn.n0 VGND 9.82521f
C223 txp.t2 VGND 0.22494f
C224 txp.t1 VGND 0.21913f
C225 txp.t0 VGND 0.11927f
C226 txp.n0 VGND 9.78623f
C227 xbuf_xn.D.t3 VGND 0.51036f
C228 xbuf_xn.D.t2 VGND 0.71942f
C229 xbuf_xn.D.t1 VGND 0.16731f
C230 xbuf_xn.D.n0 VGND 24.4861f
C231 xbuf_xn.D.t0 VGND 0.3736f
C232 xi0_xn.D.n0 VGND 21.9456f
C233 xi0_xn.D.n1 VGND 10.4276f
C234 xi0_xn.D.t0 VGND 0.73299f
C235 xi0_xn.D.t6 VGND 0.43946f
C236 xi0_xn.D.t5 VGND 0.59002f
C237 xi0_xn.D.t2 VGND 0.25381f
C238 xi0_xn.D.t3 VGND 0.44697f
C239 xi0_xn.D.t1 VGND 0.60391f
C240 xi0_xn.D.t4 VGND 0.83104f
C241 xi1_xn.D.n0 VGND 24.0171f
C242 xi1_xn.D.t0 VGND 0.64664f
C243 xi1_xn.D.t2 VGND 1.23558f
C244 xi1_xn.D.t3 VGND 1.56239f
C245 xi1_xn.D.t1 VGND 0.48203f
C246 xi1_xn.D.t4 VGND 0.67045f
C247 xib_xn.D.t3 VGND 0.34855f
C248 xib_xn.D.t2 VGND 0.34324f
C249 xib_xn.D.t0 VGND 0.21117f
C250 xib_xn.D.n0 VGND 22.7689f
C251 xib_xn.D.t1 VGND 0.41729f
C252 xis_xn.D.t3 VGND 0.46999f
C253 xis_xn.D.t2 VGND 0.6563f
C254 xis_xn.D.t1 VGND 0.17317f
C255 xis_xn.D.n0 VGND 24.4433f
C256 xis_xn.D.t0 VGND 0.38451f
C257 xis_xn.G.t1 VGND 0.91251f
C258 xis_xn.G.t3 VGND 0.55837f
C259 xis_xn.G.t2 VGND 0.80331f
C260 xis_xn.G.n0 VGND 22.1139f
C261 xis_xn.G.t0 VGND 0.64512f
C262 xn1.D.t2 VGND 0.76671f
C263 xn1.D.t3 VGND 1.69577f
C264 xn1.D.t1 VGND 1.69109f
C265 xn1.D.n0 VGND 17.7471f
C266 xn1.D.t0 VGND 0.54482f
C267 xn1.S.t0 VGND 8.49486f
C268 xn1.S.t2 VGND 7.84239f
C269 xn1.S.t1 VGND 7.91105f
C270 xtn_xn.S.t0 VGND 10.1632f
C271 xtn_xn.S.t1 VGND 16.2816f
C272 xtn_xn.S.t2 VGND 15.2197f
C273 xtp_xn.S.t0 VGND 5.56858f
C274 xtp_xn.S.t1 VGND 8.94435f
C275 xtp_xn.S.t2 VGND 8.35357f
.ends
